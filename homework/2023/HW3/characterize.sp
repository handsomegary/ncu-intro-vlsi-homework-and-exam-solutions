* 2023 HW3: TT, 1.8V, 25C; model remains external.
.protect
.lib 'D:/cic018.l' TT
.unprotect
.include 'rca.sp'
VDD vdd 0 1.8
.option post=0 measform=3 measdgt=10 numdgt=10 delmax=2p
.temp 25
XADD cin x0 x1 x2 y0 y1 y2 s0 s1 s2 cout vdd 0 rca
Cs0 s0 0 1f
Cs1 s1 0 1f
Cs2 s2 0 1f
Ccout cout 0 1f
.param x0a=0 x0b=0 x1a=0 x1b=0 x2a=0 x2b=0 y0a=0 y0b=0 y1a=0 y1b=0 y2a=0 y2b=0 cina=0 cinb=0
VREF ref 0 pwl(0 0 1n 0 1.02n 1.8 3n 1.8)
Vx0 x0 0 pwl(0 'x0a' 1n 'x0a' 1.02n 'x0b' 3n 'x0b')
Vx1 x1 0 pwl(0 'x1a' 1n 'x1a' 1.02n 'x1b' 3n 'x1b')
Vx2 x2 0 pwl(0 'x2a' 1n 'x2a' 1.02n 'x2b' 3n 'x2b')
Vy0 y0 0 pwl(0 'y0a' 1n 'y0a' 1.02n 'y0b' 3n 'y0b')
Vy1 y1 0 pwl(0 'y1a' 1n 'y1a' 1.02n 'y1b' 3n 'y1b')
Vy2 y2 0 pwl(0 'y2a' 1n 'y2a' 1.02n 'y2b' 3n 'y2b')
Vcin cin 0 pwl(0 'cina' 1n 'cina' 1.02n 'cinb' 3n 'cinb')
.data CASES caseid x0a x0b x1a x1b x2a x2b y0a y0b y1a y1b y2a y2b cina cinb
1 0 1.8 0 0 0 0 0 0 0 0 0 0 0 0
2 0 0 0 1.8 0 0 0 0 0 0 0 0 0 0
3 0 0 0 0 0 1.8 0 0 0 0 0 0 0 0
4 0 0 0 0 0 0 0 1.8 0 0 0 0 0 0
5 0 0 0 0 0 0 0 0 0 1.8 0 0 0 0
6 0 0 0 0 0 0 0 0 0 0 0 1.8 0 0
7 0 0 0 0 0 0 0 0 0 0 0 0 0 1.8
8 1.8 0 0 0 0 0 0 0 0 0 0 0 0 0
9 1.8 1.8 0 1.8 0 0 0 0 0 0 0 0 0 0
10 1.8 1.8 0 0 0 1.8 0 0 0 0 0 0 0 0
11 1.8 1.8 0 0 0 0 0 1.8 0 0 0 0 0 0
12 1.8 1.8 0 0 0 0 0 0 0 1.8 0 0 0 0
13 1.8 1.8 0 0 0 0 0 0 0 0 0 1.8 0 0
14 1.8 1.8 0 0 0 0 0 0 0 0 0 0 0 1.8
15 0 1.8 1.8 1.8 0 0 0 0 0 0 0 0 0 0
16 0 0 1.8 0 0 0 0 0 0 0 0 0 0 0
17 0 0 1.8 1.8 0 1.8 0 0 0 0 0 0 0 0
18 0 0 1.8 1.8 0 0 0 1.8 0 0 0 0 0 0
19 0 0 1.8 1.8 0 0 0 0 0 1.8 0 0 0 0
20 0 0 1.8 1.8 0 0 0 0 0 0 0 1.8 0 0
21 0 0 1.8 1.8 0 0 0 0 0 0 0 0 0 1.8
22 1.8 0 1.8 1.8 0 0 0 0 0 0 0 0 0 0
23 1.8 1.8 1.8 0 0 0 0 0 0 0 0 0 0 0
24 1.8 1.8 1.8 1.8 0 1.8 0 0 0 0 0 0 0 0
25 1.8 1.8 1.8 1.8 0 0 0 1.8 0 0 0 0 0 0
26 1.8 1.8 1.8 1.8 0 0 0 0 0 1.8 0 0 0 0
27 1.8 1.8 1.8 1.8 0 0 0 0 0 0 0 1.8 0 0
28 1.8 1.8 1.8 1.8 0 0 0 0 0 0 0 0 0 1.8
29 0 1.8 0 0 1.8 1.8 0 0 0 0 0 0 0 0
30 0 0 0 1.8 1.8 1.8 0 0 0 0 0 0 0 0
31 0 0 0 0 1.8 0 0 0 0 0 0 0 0 0
32 0 0 0 0 1.8 1.8 0 1.8 0 0 0 0 0 0
33 0 0 0 0 1.8 1.8 0 0 0 1.8 0 0 0 0
34 0 0 0 0 1.8 1.8 0 0 0 0 0 1.8 0 0
35 0 0 0 0 1.8 1.8 0 0 0 0 0 0 0 1.8
36 1.8 0 0 0 1.8 1.8 0 0 0 0 0 0 0 0
37 1.8 1.8 0 1.8 1.8 1.8 0 0 0 0 0 0 0 0
38 1.8 1.8 0 0 1.8 0 0 0 0 0 0 0 0 0
39 1.8 1.8 0 0 1.8 1.8 0 1.8 0 0 0 0 0 0
40 1.8 1.8 0 0 1.8 1.8 0 0 0 1.8 0 0 0 0
41 1.8 1.8 0 0 1.8 1.8 0 0 0 0 0 1.8 0 0
42 1.8 1.8 0 0 1.8 1.8 0 0 0 0 0 0 0 1.8
43 0 1.8 1.8 1.8 1.8 1.8 0 0 0 0 0 0 0 0
44 0 0 1.8 0 1.8 1.8 0 0 0 0 0 0 0 0
45 0 0 1.8 1.8 1.8 0 0 0 0 0 0 0 0 0
46 0 0 1.8 1.8 1.8 1.8 0 1.8 0 0 0 0 0 0
47 0 0 1.8 1.8 1.8 1.8 0 0 0 1.8 0 0 0 0
48 0 0 1.8 1.8 1.8 1.8 0 0 0 0 0 1.8 0 0
49 0 0 1.8 1.8 1.8 1.8 0 0 0 0 0 0 0 1.8
50 1.8 0 1.8 1.8 1.8 1.8 0 0 0 0 0 0 0 0
51 1.8 1.8 1.8 0 1.8 1.8 0 0 0 0 0 0 0 0
52 1.8 1.8 1.8 1.8 1.8 0 0 0 0 0 0 0 0 0
53 1.8 1.8 1.8 1.8 1.8 1.8 0 1.8 0 0 0 0 0 0
54 1.8 1.8 1.8 1.8 1.8 1.8 0 0 0 1.8 0 0 0 0
55 1.8 1.8 1.8 1.8 1.8 1.8 0 0 0 0 0 1.8 0 0
56 1.8 1.8 1.8 1.8 1.8 1.8 0 0 0 0 0 0 0 1.8
57 0 1.8 0 0 0 0 1.8 1.8 0 0 0 0 0 0
58 0 0 0 1.8 0 0 1.8 1.8 0 0 0 0 0 0
59 0 0 0 0 0 1.8 1.8 1.8 0 0 0 0 0 0
60 0 0 0 0 0 0 1.8 0 0 0 0 0 0 0
61 0 0 0 0 0 0 1.8 1.8 0 1.8 0 0 0 0
62 0 0 0 0 0 0 1.8 1.8 0 0 0 1.8 0 0
63 0 0 0 0 0 0 1.8 1.8 0 0 0 0 0 1.8
64 1.8 0 0 0 0 0 1.8 1.8 0 0 0 0 0 0
65 1.8 1.8 0 1.8 0 0 1.8 1.8 0 0 0 0 0 0
66 1.8 1.8 0 0 0 1.8 1.8 1.8 0 0 0 0 0 0
67 1.8 1.8 0 0 0 0 1.8 0 0 0 0 0 0 0
68 1.8 1.8 0 0 0 0 1.8 1.8 0 1.8 0 0 0 0
69 1.8 1.8 0 0 0 0 1.8 1.8 0 0 0 1.8 0 0
70 1.8 1.8 0 0 0 0 1.8 1.8 0 0 0 0 0 1.8
71 0 1.8 1.8 1.8 0 0 1.8 1.8 0 0 0 0 0 0
72 0 0 1.8 0 0 0 1.8 1.8 0 0 0 0 0 0
73 0 0 1.8 1.8 0 1.8 1.8 1.8 0 0 0 0 0 0
74 0 0 1.8 1.8 0 0 1.8 0 0 0 0 0 0 0
75 0 0 1.8 1.8 0 0 1.8 1.8 0 1.8 0 0 0 0
76 0 0 1.8 1.8 0 0 1.8 1.8 0 0 0 1.8 0 0
77 0 0 1.8 1.8 0 0 1.8 1.8 0 0 0 0 0 1.8
78 1.8 0 1.8 1.8 0 0 1.8 1.8 0 0 0 0 0 0
79 1.8 1.8 1.8 0 0 0 1.8 1.8 0 0 0 0 0 0
80 1.8 1.8 1.8 1.8 0 1.8 1.8 1.8 0 0 0 0 0 0
81 1.8 1.8 1.8 1.8 0 0 1.8 0 0 0 0 0 0 0
82 1.8 1.8 1.8 1.8 0 0 1.8 1.8 0 1.8 0 0 0 0
83 1.8 1.8 1.8 1.8 0 0 1.8 1.8 0 0 0 1.8 0 0
84 1.8 1.8 1.8 1.8 0 0 1.8 1.8 0 0 0 0 0 1.8
85 0 1.8 0 0 1.8 1.8 1.8 1.8 0 0 0 0 0 0
86 0 0 0 1.8 1.8 1.8 1.8 1.8 0 0 0 0 0 0
87 0 0 0 0 1.8 0 1.8 1.8 0 0 0 0 0 0
88 0 0 0 0 1.8 1.8 1.8 0 0 0 0 0 0 0
89 0 0 0 0 1.8 1.8 1.8 1.8 0 1.8 0 0 0 0
90 0 0 0 0 1.8 1.8 1.8 1.8 0 0 0 1.8 0 0
91 0 0 0 0 1.8 1.8 1.8 1.8 0 0 0 0 0 1.8
92 1.8 0 0 0 1.8 1.8 1.8 1.8 0 0 0 0 0 0
93 1.8 1.8 0 1.8 1.8 1.8 1.8 1.8 0 0 0 0 0 0
94 1.8 1.8 0 0 1.8 0 1.8 1.8 0 0 0 0 0 0
95 1.8 1.8 0 0 1.8 1.8 1.8 0 0 0 0 0 0 0
96 1.8 1.8 0 0 1.8 1.8 1.8 1.8 0 1.8 0 0 0 0
97 1.8 1.8 0 0 1.8 1.8 1.8 1.8 0 0 0 1.8 0 0
98 1.8 1.8 0 0 1.8 1.8 1.8 1.8 0 0 0 0 0 1.8
99 0 1.8 1.8 1.8 1.8 1.8 1.8 1.8 0 0 0 0 0 0
100 0 0 1.8 0 1.8 1.8 1.8 1.8 0 0 0 0 0 0
101 0 0 1.8 1.8 1.8 0 1.8 1.8 0 0 0 0 0 0
102 0 0 1.8 1.8 1.8 1.8 1.8 0 0 0 0 0 0 0
103 0 0 1.8 1.8 1.8 1.8 1.8 1.8 0 1.8 0 0 0 0
104 0 0 1.8 1.8 1.8 1.8 1.8 1.8 0 0 0 1.8 0 0
105 0 0 1.8 1.8 1.8 1.8 1.8 1.8 0 0 0 0 0 1.8
106 1.8 0 1.8 1.8 1.8 1.8 1.8 1.8 0 0 0 0 0 0
107 1.8 1.8 1.8 0 1.8 1.8 1.8 1.8 0 0 0 0 0 0
108 1.8 1.8 1.8 1.8 1.8 0 1.8 1.8 0 0 0 0 0 0
109 1.8 1.8 1.8 1.8 1.8 1.8 1.8 0 0 0 0 0 0 0
110 1.8 1.8 1.8 1.8 1.8 1.8 1.8 1.8 0 1.8 0 0 0 0
111 1.8 1.8 1.8 1.8 1.8 1.8 1.8 1.8 0 0 0 1.8 0 0
112 1.8 1.8 1.8 1.8 1.8 1.8 1.8 1.8 0 0 0 0 0 1.8
113 0 1.8 0 0 0 0 0 0 1.8 1.8 0 0 0 0
114 0 0 0 1.8 0 0 0 0 1.8 1.8 0 0 0 0
115 0 0 0 0 0 1.8 0 0 1.8 1.8 0 0 0 0
116 0 0 0 0 0 0 0 1.8 1.8 1.8 0 0 0 0
117 0 0 0 0 0 0 0 0 1.8 0 0 0 0 0
118 0 0 0 0 0 0 0 0 1.8 1.8 0 1.8 0 0
119 0 0 0 0 0 0 0 0 1.8 1.8 0 0 0 1.8
120 1.8 0 0 0 0 0 0 0 1.8 1.8 0 0 0 0
121 1.8 1.8 0 1.8 0 0 0 0 1.8 1.8 0 0 0 0
122 1.8 1.8 0 0 0 1.8 0 0 1.8 1.8 0 0 0 0
123 1.8 1.8 0 0 0 0 0 1.8 1.8 1.8 0 0 0 0
124 1.8 1.8 0 0 0 0 0 0 1.8 0 0 0 0 0
125 1.8 1.8 0 0 0 0 0 0 1.8 1.8 0 1.8 0 0
126 1.8 1.8 0 0 0 0 0 0 1.8 1.8 0 0 0 1.8
127 0 1.8 1.8 1.8 0 0 0 0 1.8 1.8 0 0 0 0
128 0 0 1.8 0 0 0 0 0 1.8 1.8 0 0 0 0
129 0 0 1.8 1.8 0 1.8 0 0 1.8 1.8 0 0 0 0
130 0 0 1.8 1.8 0 0 0 1.8 1.8 1.8 0 0 0 0
131 0 0 1.8 1.8 0 0 0 0 1.8 0 0 0 0 0
132 0 0 1.8 1.8 0 0 0 0 1.8 1.8 0 1.8 0 0
133 0 0 1.8 1.8 0 0 0 0 1.8 1.8 0 0 0 1.8
134 1.8 0 1.8 1.8 0 0 0 0 1.8 1.8 0 0 0 0
135 1.8 1.8 1.8 0 0 0 0 0 1.8 1.8 0 0 0 0
136 1.8 1.8 1.8 1.8 0 1.8 0 0 1.8 1.8 0 0 0 0
137 1.8 1.8 1.8 1.8 0 0 0 1.8 1.8 1.8 0 0 0 0
138 1.8 1.8 1.8 1.8 0 0 0 0 1.8 0 0 0 0 0
139 1.8 1.8 1.8 1.8 0 0 0 0 1.8 1.8 0 1.8 0 0
140 1.8 1.8 1.8 1.8 0 0 0 0 1.8 1.8 0 0 0 1.8
141 0 1.8 0 0 1.8 1.8 0 0 1.8 1.8 0 0 0 0
142 0 0 0 1.8 1.8 1.8 0 0 1.8 1.8 0 0 0 0
143 0 0 0 0 1.8 0 0 0 1.8 1.8 0 0 0 0
144 0 0 0 0 1.8 1.8 0 1.8 1.8 1.8 0 0 0 0
145 0 0 0 0 1.8 1.8 0 0 1.8 0 0 0 0 0
146 0 0 0 0 1.8 1.8 0 0 1.8 1.8 0 1.8 0 0
147 0 0 0 0 1.8 1.8 0 0 1.8 1.8 0 0 0 1.8
148 1.8 0 0 0 1.8 1.8 0 0 1.8 1.8 0 0 0 0
149 1.8 1.8 0 1.8 1.8 1.8 0 0 1.8 1.8 0 0 0 0
150 1.8 1.8 0 0 1.8 0 0 0 1.8 1.8 0 0 0 0
151 1.8 1.8 0 0 1.8 1.8 0 1.8 1.8 1.8 0 0 0 0
152 1.8 1.8 0 0 1.8 1.8 0 0 1.8 0 0 0 0 0
153 1.8 1.8 0 0 1.8 1.8 0 0 1.8 1.8 0 1.8 0 0
154 1.8 1.8 0 0 1.8 1.8 0 0 1.8 1.8 0 0 0 1.8
155 0 1.8 1.8 1.8 1.8 1.8 0 0 1.8 1.8 0 0 0 0
156 0 0 1.8 0 1.8 1.8 0 0 1.8 1.8 0 0 0 0
157 0 0 1.8 1.8 1.8 0 0 0 1.8 1.8 0 0 0 0
158 0 0 1.8 1.8 1.8 1.8 0 1.8 1.8 1.8 0 0 0 0
159 0 0 1.8 1.8 1.8 1.8 0 0 1.8 0 0 0 0 0
160 0 0 1.8 1.8 1.8 1.8 0 0 1.8 1.8 0 1.8 0 0
161 0 0 1.8 1.8 1.8 1.8 0 0 1.8 1.8 0 0 0 1.8
162 1.8 0 1.8 1.8 1.8 1.8 0 0 1.8 1.8 0 0 0 0
163 1.8 1.8 1.8 0 1.8 1.8 0 0 1.8 1.8 0 0 0 0
164 1.8 1.8 1.8 1.8 1.8 0 0 0 1.8 1.8 0 0 0 0
165 1.8 1.8 1.8 1.8 1.8 1.8 0 1.8 1.8 1.8 0 0 0 0
166 1.8 1.8 1.8 1.8 1.8 1.8 0 0 1.8 0 0 0 0 0
167 1.8 1.8 1.8 1.8 1.8 1.8 0 0 1.8 1.8 0 1.8 0 0
168 1.8 1.8 1.8 1.8 1.8 1.8 0 0 1.8 1.8 0 0 0 1.8
169 0 1.8 0 0 0 0 1.8 1.8 1.8 1.8 0 0 0 0
170 0 0 0 1.8 0 0 1.8 1.8 1.8 1.8 0 0 0 0
171 0 0 0 0 0 1.8 1.8 1.8 1.8 1.8 0 0 0 0
172 0 0 0 0 0 0 1.8 0 1.8 1.8 0 0 0 0
173 0 0 0 0 0 0 1.8 1.8 1.8 0 0 0 0 0
174 0 0 0 0 0 0 1.8 1.8 1.8 1.8 0 1.8 0 0
175 0 0 0 0 0 0 1.8 1.8 1.8 1.8 0 0 0 1.8
176 1.8 0 0 0 0 0 1.8 1.8 1.8 1.8 0 0 0 0
177 1.8 1.8 0 1.8 0 0 1.8 1.8 1.8 1.8 0 0 0 0
178 1.8 1.8 0 0 0 1.8 1.8 1.8 1.8 1.8 0 0 0 0
179 1.8 1.8 0 0 0 0 1.8 0 1.8 1.8 0 0 0 0
180 1.8 1.8 0 0 0 0 1.8 1.8 1.8 0 0 0 0 0
181 1.8 1.8 0 0 0 0 1.8 1.8 1.8 1.8 0 1.8 0 0
182 1.8 1.8 0 0 0 0 1.8 1.8 1.8 1.8 0 0 0 1.8
183 0 1.8 1.8 1.8 0 0 1.8 1.8 1.8 1.8 0 0 0 0
184 0 0 1.8 0 0 0 1.8 1.8 1.8 1.8 0 0 0 0
185 0 0 1.8 1.8 0 1.8 1.8 1.8 1.8 1.8 0 0 0 0
186 0 0 1.8 1.8 0 0 1.8 0 1.8 1.8 0 0 0 0
187 0 0 1.8 1.8 0 0 1.8 1.8 1.8 0 0 0 0 0
188 0 0 1.8 1.8 0 0 1.8 1.8 1.8 1.8 0 1.8 0 0
189 0 0 1.8 1.8 0 0 1.8 1.8 1.8 1.8 0 0 0 1.8
190 1.8 0 1.8 1.8 0 0 1.8 1.8 1.8 1.8 0 0 0 0
191 1.8 1.8 1.8 0 0 0 1.8 1.8 1.8 1.8 0 0 0 0
192 1.8 1.8 1.8 1.8 0 1.8 1.8 1.8 1.8 1.8 0 0 0 0
193 1.8 1.8 1.8 1.8 0 0 1.8 0 1.8 1.8 0 0 0 0
194 1.8 1.8 1.8 1.8 0 0 1.8 1.8 1.8 0 0 0 0 0
195 1.8 1.8 1.8 1.8 0 0 1.8 1.8 1.8 1.8 0 1.8 0 0
196 1.8 1.8 1.8 1.8 0 0 1.8 1.8 1.8 1.8 0 0 0 1.8
197 0 1.8 0 0 1.8 1.8 1.8 1.8 1.8 1.8 0 0 0 0
198 0 0 0 1.8 1.8 1.8 1.8 1.8 1.8 1.8 0 0 0 0
199 0 0 0 0 1.8 0 1.8 1.8 1.8 1.8 0 0 0 0
200 0 0 0 0 1.8 1.8 1.8 0 1.8 1.8 0 0 0 0
201 0 0 0 0 1.8 1.8 1.8 1.8 1.8 0 0 0 0 0
202 0 0 0 0 1.8 1.8 1.8 1.8 1.8 1.8 0 1.8 0 0
203 0 0 0 0 1.8 1.8 1.8 1.8 1.8 1.8 0 0 0 1.8
204 1.8 0 0 0 1.8 1.8 1.8 1.8 1.8 1.8 0 0 0 0
205 1.8 1.8 0 1.8 1.8 1.8 1.8 1.8 1.8 1.8 0 0 0 0
206 1.8 1.8 0 0 1.8 0 1.8 1.8 1.8 1.8 0 0 0 0
207 1.8 1.8 0 0 1.8 1.8 1.8 0 1.8 1.8 0 0 0 0
208 1.8 1.8 0 0 1.8 1.8 1.8 1.8 1.8 0 0 0 0 0
209 1.8 1.8 0 0 1.8 1.8 1.8 1.8 1.8 1.8 0 1.8 0 0
210 1.8 1.8 0 0 1.8 1.8 1.8 1.8 1.8 1.8 0 0 0 1.8
211 0 1.8 1.8 1.8 1.8 1.8 1.8 1.8 1.8 1.8 0 0 0 0
212 0 0 1.8 0 1.8 1.8 1.8 1.8 1.8 1.8 0 0 0 0
213 0 0 1.8 1.8 1.8 0 1.8 1.8 1.8 1.8 0 0 0 0
214 0 0 1.8 1.8 1.8 1.8 1.8 0 1.8 1.8 0 0 0 0
215 0 0 1.8 1.8 1.8 1.8 1.8 1.8 1.8 0 0 0 0 0
216 0 0 1.8 1.8 1.8 1.8 1.8 1.8 1.8 1.8 0 1.8 0 0
217 0 0 1.8 1.8 1.8 1.8 1.8 1.8 1.8 1.8 0 0 0 1.8
218 1.8 0 1.8 1.8 1.8 1.8 1.8 1.8 1.8 1.8 0 0 0 0
219 1.8 1.8 1.8 0 1.8 1.8 1.8 1.8 1.8 1.8 0 0 0 0
220 1.8 1.8 1.8 1.8 1.8 0 1.8 1.8 1.8 1.8 0 0 0 0
221 1.8 1.8 1.8 1.8 1.8 1.8 1.8 0 1.8 1.8 0 0 0 0
222 1.8 1.8 1.8 1.8 1.8 1.8 1.8 1.8 1.8 0 0 0 0 0
223 1.8 1.8 1.8 1.8 1.8 1.8 1.8 1.8 1.8 1.8 0 1.8 0 0
224 1.8 1.8 1.8 1.8 1.8 1.8 1.8 1.8 1.8 1.8 0 0 0 1.8
225 0 1.8 0 0 0 0 0 0 0 0 1.8 1.8 0 0
226 0 0 0 1.8 0 0 0 0 0 0 1.8 1.8 0 0
227 0 0 0 0 0 1.8 0 0 0 0 1.8 1.8 0 0
228 0 0 0 0 0 0 0 1.8 0 0 1.8 1.8 0 0
229 0 0 0 0 0 0 0 0 0 1.8 1.8 1.8 0 0
230 0 0 0 0 0 0 0 0 0 0 1.8 0 0 0
231 0 0 0 0 0 0 0 0 0 0 1.8 1.8 0 1.8
232 1.8 0 0 0 0 0 0 0 0 0 1.8 1.8 0 0
233 1.8 1.8 0 1.8 0 0 0 0 0 0 1.8 1.8 0 0
234 1.8 1.8 0 0 0 1.8 0 0 0 0 1.8 1.8 0 0
235 1.8 1.8 0 0 0 0 0 1.8 0 0 1.8 1.8 0 0
236 1.8 1.8 0 0 0 0 0 0 0 1.8 1.8 1.8 0 0
237 1.8 1.8 0 0 0 0 0 0 0 0 1.8 0 0 0
238 1.8 1.8 0 0 0 0 0 0 0 0 1.8 1.8 0 1.8
239 0 1.8 1.8 1.8 0 0 0 0 0 0 1.8 1.8 0 0
240 0 0 1.8 0 0 0 0 0 0 0 1.8 1.8 0 0
241 0 0 1.8 1.8 0 1.8 0 0 0 0 1.8 1.8 0 0
242 0 0 1.8 1.8 0 0 0 1.8 0 0 1.8 1.8 0 0
243 0 0 1.8 1.8 0 0 0 0 0 1.8 1.8 1.8 0 0
244 0 0 1.8 1.8 0 0 0 0 0 0 1.8 0 0 0
245 0 0 1.8 1.8 0 0 0 0 0 0 1.8 1.8 0 1.8
246 1.8 0 1.8 1.8 0 0 0 0 0 0 1.8 1.8 0 0
247 1.8 1.8 1.8 0 0 0 0 0 0 0 1.8 1.8 0 0
248 1.8 1.8 1.8 1.8 0 1.8 0 0 0 0 1.8 1.8 0 0
249 1.8 1.8 1.8 1.8 0 0 0 1.8 0 0 1.8 1.8 0 0
250 1.8 1.8 1.8 1.8 0 0 0 0 0 1.8 1.8 1.8 0 0
251 1.8 1.8 1.8 1.8 0 0 0 0 0 0 1.8 0 0 0
252 1.8 1.8 1.8 1.8 0 0 0 0 0 0 1.8 1.8 0 1.8
253 0 1.8 0 0 1.8 1.8 0 0 0 0 1.8 1.8 0 0
254 0 0 0 1.8 1.8 1.8 0 0 0 0 1.8 1.8 0 0
255 0 0 0 0 1.8 0 0 0 0 0 1.8 1.8 0 0
256 0 0 0 0 1.8 1.8 0 1.8 0 0 1.8 1.8 0 0
257 0 0 0 0 1.8 1.8 0 0 0 1.8 1.8 1.8 0 0
258 0 0 0 0 1.8 1.8 0 0 0 0 1.8 0 0 0
259 0 0 0 0 1.8 1.8 0 0 0 0 1.8 1.8 0 1.8
260 1.8 0 0 0 1.8 1.8 0 0 0 0 1.8 1.8 0 0
261 1.8 1.8 0 1.8 1.8 1.8 0 0 0 0 1.8 1.8 0 0
262 1.8 1.8 0 0 1.8 0 0 0 0 0 1.8 1.8 0 0
263 1.8 1.8 0 0 1.8 1.8 0 1.8 0 0 1.8 1.8 0 0
264 1.8 1.8 0 0 1.8 1.8 0 0 0 1.8 1.8 1.8 0 0
265 1.8 1.8 0 0 1.8 1.8 0 0 0 0 1.8 0 0 0
266 1.8 1.8 0 0 1.8 1.8 0 0 0 0 1.8 1.8 0 1.8
267 0 1.8 1.8 1.8 1.8 1.8 0 0 0 0 1.8 1.8 0 0
268 0 0 1.8 0 1.8 1.8 0 0 0 0 1.8 1.8 0 0
269 0 0 1.8 1.8 1.8 0 0 0 0 0 1.8 1.8 0 0
270 0 0 1.8 1.8 1.8 1.8 0 1.8 0 0 1.8 1.8 0 0
271 0 0 1.8 1.8 1.8 1.8 0 0 0 1.8 1.8 1.8 0 0
272 0 0 1.8 1.8 1.8 1.8 0 0 0 0 1.8 0 0 0
273 0 0 1.8 1.8 1.8 1.8 0 0 0 0 1.8 1.8 0 1.8
274 1.8 0 1.8 1.8 1.8 1.8 0 0 0 0 1.8 1.8 0 0
275 1.8 1.8 1.8 0 1.8 1.8 0 0 0 0 1.8 1.8 0 0
276 1.8 1.8 1.8 1.8 1.8 0 0 0 0 0 1.8 1.8 0 0
277 1.8 1.8 1.8 1.8 1.8 1.8 0 1.8 0 0 1.8 1.8 0 0
278 1.8 1.8 1.8 1.8 1.8 1.8 0 0 0 1.8 1.8 1.8 0 0
279 1.8 1.8 1.8 1.8 1.8 1.8 0 0 0 0 1.8 0 0 0
280 1.8 1.8 1.8 1.8 1.8 1.8 0 0 0 0 1.8 1.8 0 1.8
281 0 1.8 0 0 0 0 1.8 1.8 0 0 1.8 1.8 0 0
282 0 0 0 1.8 0 0 1.8 1.8 0 0 1.8 1.8 0 0
283 0 0 0 0 0 1.8 1.8 1.8 0 0 1.8 1.8 0 0
284 0 0 0 0 0 0 1.8 0 0 0 1.8 1.8 0 0
285 0 0 0 0 0 0 1.8 1.8 0 1.8 1.8 1.8 0 0
286 0 0 0 0 0 0 1.8 1.8 0 0 1.8 0 0 0
287 0 0 0 0 0 0 1.8 1.8 0 0 1.8 1.8 0 1.8
288 1.8 0 0 0 0 0 1.8 1.8 0 0 1.8 1.8 0 0
289 1.8 1.8 0 1.8 0 0 1.8 1.8 0 0 1.8 1.8 0 0
290 1.8 1.8 0 0 0 1.8 1.8 1.8 0 0 1.8 1.8 0 0
291 1.8 1.8 0 0 0 0 1.8 0 0 0 1.8 1.8 0 0
292 1.8 1.8 0 0 0 0 1.8 1.8 0 1.8 1.8 1.8 0 0
293 1.8 1.8 0 0 0 0 1.8 1.8 0 0 1.8 0 0 0
294 1.8 1.8 0 0 0 0 1.8 1.8 0 0 1.8 1.8 0 1.8
295 0 1.8 1.8 1.8 0 0 1.8 1.8 0 0 1.8 1.8 0 0
296 0 0 1.8 0 0 0 1.8 1.8 0 0 1.8 1.8 0 0
297 0 0 1.8 1.8 0 1.8 1.8 1.8 0 0 1.8 1.8 0 0
298 0 0 1.8 1.8 0 0 1.8 0 0 0 1.8 1.8 0 0
299 0 0 1.8 1.8 0 0 1.8 1.8 0 1.8 1.8 1.8 0 0
300 0 0 1.8 1.8 0 0 1.8 1.8 0 0 1.8 0 0 0
301 0 0 1.8 1.8 0 0 1.8 1.8 0 0 1.8 1.8 0 1.8
302 1.8 0 1.8 1.8 0 0 1.8 1.8 0 0 1.8 1.8 0 0
303 1.8 1.8 1.8 0 0 0 1.8 1.8 0 0 1.8 1.8 0 0
304 1.8 1.8 1.8 1.8 0 1.8 1.8 1.8 0 0 1.8 1.8 0 0
305 1.8 1.8 1.8 1.8 0 0 1.8 0 0 0 1.8 1.8 0 0
306 1.8 1.8 1.8 1.8 0 0 1.8 1.8 0 1.8 1.8 1.8 0 0
307 1.8 1.8 1.8 1.8 0 0 1.8 1.8 0 0 1.8 0 0 0
308 1.8 1.8 1.8 1.8 0 0 1.8 1.8 0 0 1.8 1.8 0 1.8
309 0 1.8 0 0 1.8 1.8 1.8 1.8 0 0 1.8 1.8 0 0
310 0 0 0 1.8 1.8 1.8 1.8 1.8 0 0 1.8 1.8 0 0
311 0 0 0 0 1.8 0 1.8 1.8 0 0 1.8 1.8 0 0
312 0 0 0 0 1.8 1.8 1.8 0 0 0 1.8 1.8 0 0
313 0 0 0 0 1.8 1.8 1.8 1.8 0 1.8 1.8 1.8 0 0
314 0 0 0 0 1.8 1.8 1.8 1.8 0 0 1.8 0 0 0
315 0 0 0 0 1.8 1.8 1.8 1.8 0 0 1.8 1.8 0 1.8
316 1.8 0 0 0 1.8 1.8 1.8 1.8 0 0 1.8 1.8 0 0
317 1.8 1.8 0 1.8 1.8 1.8 1.8 1.8 0 0 1.8 1.8 0 0
318 1.8 1.8 0 0 1.8 0 1.8 1.8 0 0 1.8 1.8 0 0
319 1.8 1.8 0 0 1.8 1.8 1.8 0 0 0 1.8 1.8 0 0
320 1.8 1.8 0 0 1.8 1.8 1.8 1.8 0 1.8 1.8 1.8 0 0
321 1.8 1.8 0 0 1.8 1.8 1.8 1.8 0 0 1.8 0 0 0
322 1.8 1.8 0 0 1.8 1.8 1.8 1.8 0 0 1.8 1.8 0 1.8
323 0 1.8 1.8 1.8 1.8 1.8 1.8 1.8 0 0 1.8 1.8 0 0
324 0 0 1.8 0 1.8 1.8 1.8 1.8 0 0 1.8 1.8 0 0
325 0 0 1.8 1.8 1.8 0 1.8 1.8 0 0 1.8 1.8 0 0
326 0 0 1.8 1.8 1.8 1.8 1.8 0 0 0 1.8 1.8 0 0
327 0 0 1.8 1.8 1.8 1.8 1.8 1.8 0 1.8 1.8 1.8 0 0
328 0 0 1.8 1.8 1.8 1.8 1.8 1.8 0 0 1.8 0 0 0
329 0 0 1.8 1.8 1.8 1.8 1.8 1.8 0 0 1.8 1.8 0 1.8
330 1.8 0 1.8 1.8 1.8 1.8 1.8 1.8 0 0 1.8 1.8 0 0
331 1.8 1.8 1.8 0 1.8 1.8 1.8 1.8 0 0 1.8 1.8 0 0
332 1.8 1.8 1.8 1.8 1.8 0 1.8 1.8 0 0 1.8 1.8 0 0
333 1.8 1.8 1.8 1.8 1.8 1.8 1.8 0 0 0 1.8 1.8 0 0
334 1.8 1.8 1.8 1.8 1.8 1.8 1.8 1.8 0 1.8 1.8 1.8 0 0
335 1.8 1.8 1.8 1.8 1.8 1.8 1.8 1.8 0 0 1.8 0 0 0
336 1.8 1.8 1.8 1.8 1.8 1.8 1.8 1.8 0 0 1.8 1.8 0 1.8
337 0 1.8 0 0 0 0 0 0 1.8 1.8 1.8 1.8 0 0
338 0 0 0 1.8 0 0 0 0 1.8 1.8 1.8 1.8 0 0
339 0 0 0 0 0 1.8 0 0 1.8 1.8 1.8 1.8 0 0
340 0 0 0 0 0 0 0 1.8 1.8 1.8 1.8 1.8 0 0
341 0 0 0 0 0 0 0 0 1.8 0 1.8 1.8 0 0
342 0 0 0 0 0 0 0 0 1.8 1.8 1.8 0 0 0
343 0 0 0 0 0 0 0 0 1.8 1.8 1.8 1.8 0 1.8
344 1.8 0 0 0 0 0 0 0 1.8 1.8 1.8 1.8 0 0
345 1.8 1.8 0 1.8 0 0 0 0 1.8 1.8 1.8 1.8 0 0
346 1.8 1.8 0 0 0 1.8 0 0 1.8 1.8 1.8 1.8 0 0
347 1.8 1.8 0 0 0 0 0 1.8 1.8 1.8 1.8 1.8 0 0
348 1.8 1.8 0 0 0 0 0 0 1.8 0 1.8 1.8 0 0
349 1.8 1.8 0 0 0 0 0 0 1.8 1.8 1.8 0 0 0
350 1.8 1.8 0 0 0 0 0 0 1.8 1.8 1.8 1.8 0 1.8
351 0 1.8 1.8 1.8 0 0 0 0 1.8 1.8 1.8 1.8 0 0
352 0 0 1.8 0 0 0 0 0 1.8 1.8 1.8 1.8 0 0
353 0 0 1.8 1.8 0 1.8 0 0 1.8 1.8 1.8 1.8 0 0
354 0 0 1.8 1.8 0 0 0 1.8 1.8 1.8 1.8 1.8 0 0
355 0 0 1.8 1.8 0 0 0 0 1.8 0 1.8 1.8 0 0
356 0 0 1.8 1.8 0 0 0 0 1.8 1.8 1.8 0 0 0
357 0 0 1.8 1.8 0 0 0 0 1.8 1.8 1.8 1.8 0 1.8
358 1.8 0 1.8 1.8 0 0 0 0 1.8 1.8 1.8 1.8 0 0
359 1.8 1.8 1.8 0 0 0 0 0 1.8 1.8 1.8 1.8 0 0
360 1.8 1.8 1.8 1.8 0 1.8 0 0 1.8 1.8 1.8 1.8 0 0
361 1.8 1.8 1.8 1.8 0 0 0 1.8 1.8 1.8 1.8 1.8 0 0
362 1.8 1.8 1.8 1.8 0 0 0 0 1.8 0 1.8 1.8 0 0
363 1.8 1.8 1.8 1.8 0 0 0 0 1.8 1.8 1.8 0 0 0
364 1.8 1.8 1.8 1.8 0 0 0 0 1.8 1.8 1.8 1.8 0 1.8
365 0 1.8 0 0 1.8 1.8 0 0 1.8 1.8 1.8 1.8 0 0
366 0 0 0 1.8 1.8 1.8 0 0 1.8 1.8 1.8 1.8 0 0
367 0 0 0 0 1.8 0 0 0 1.8 1.8 1.8 1.8 0 0
368 0 0 0 0 1.8 1.8 0 1.8 1.8 1.8 1.8 1.8 0 0
369 0 0 0 0 1.8 1.8 0 0 1.8 0 1.8 1.8 0 0
370 0 0 0 0 1.8 1.8 0 0 1.8 1.8 1.8 0 0 0
371 0 0 0 0 1.8 1.8 0 0 1.8 1.8 1.8 1.8 0 1.8
372 1.8 0 0 0 1.8 1.8 0 0 1.8 1.8 1.8 1.8 0 0
373 1.8 1.8 0 1.8 1.8 1.8 0 0 1.8 1.8 1.8 1.8 0 0
374 1.8 1.8 0 0 1.8 0 0 0 1.8 1.8 1.8 1.8 0 0
375 1.8 1.8 0 0 1.8 1.8 0 1.8 1.8 1.8 1.8 1.8 0 0
376 1.8 1.8 0 0 1.8 1.8 0 0 1.8 0 1.8 1.8 0 0
377 1.8 1.8 0 0 1.8 1.8 0 0 1.8 1.8 1.8 0 0 0
378 1.8 1.8 0 0 1.8 1.8 0 0 1.8 1.8 1.8 1.8 0 1.8
379 0 1.8 1.8 1.8 1.8 1.8 0 0 1.8 1.8 1.8 1.8 0 0
380 0 0 1.8 0 1.8 1.8 0 0 1.8 1.8 1.8 1.8 0 0
381 0 0 1.8 1.8 1.8 0 0 0 1.8 1.8 1.8 1.8 0 0
382 0 0 1.8 1.8 1.8 1.8 0 1.8 1.8 1.8 1.8 1.8 0 0
383 0 0 1.8 1.8 1.8 1.8 0 0 1.8 0 1.8 1.8 0 0
384 0 0 1.8 1.8 1.8 1.8 0 0 1.8 1.8 1.8 0 0 0
385 0 0 1.8 1.8 1.8 1.8 0 0 1.8 1.8 1.8 1.8 0 1.8
386 1.8 0 1.8 1.8 1.8 1.8 0 0 1.8 1.8 1.8 1.8 0 0
387 1.8 1.8 1.8 0 1.8 1.8 0 0 1.8 1.8 1.8 1.8 0 0
388 1.8 1.8 1.8 1.8 1.8 0 0 0 1.8 1.8 1.8 1.8 0 0
389 1.8 1.8 1.8 1.8 1.8 1.8 0 1.8 1.8 1.8 1.8 1.8 0 0
390 1.8 1.8 1.8 1.8 1.8 1.8 0 0 1.8 0 1.8 1.8 0 0
391 1.8 1.8 1.8 1.8 1.8 1.8 0 0 1.8 1.8 1.8 0 0 0
392 1.8 1.8 1.8 1.8 1.8 1.8 0 0 1.8 1.8 1.8 1.8 0 1.8
393 0 1.8 0 0 0 0 1.8 1.8 1.8 1.8 1.8 1.8 0 0
394 0 0 0 1.8 0 0 1.8 1.8 1.8 1.8 1.8 1.8 0 0
395 0 0 0 0 0 1.8 1.8 1.8 1.8 1.8 1.8 1.8 0 0
396 0 0 0 0 0 0 1.8 0 1.8 1.8 1.8 1.8 0 0
397 0 0 0 0 0 0 1.8 1.8 1.8 0 1.8 1.8 0 0
398 0 0 0 0 0 0 1.8 1.8 1.8 1.8 1.8 0 0 0
399 0 0 0 0 0 0 1.8 1.8 1.8 1.8 1.8 1.8 0 1.8
400 1.8 0 0 0 0 0 1.8 1.8 1.8 1.8 1.8 1.8 0 0
401 1.8 1.8 0 1.8 0 0 1.8 1.8 1.8 1.8 1.8 1.8 0 0
402 1.8 1.8 0 0 0 1.8 1.8 1.8 1.8 1.8 1.8 1.8 0 0
403 1.8 1.8 0 0 0 0 1.8 0 1.8 1.8 1.8 1.8 0 0
404 1.8 1.8 0 0 0 0 1.8 1.8 1.8 0 1.8 1.8 0 0
405 1.8 1.8 0 0 0 0 1.8 1.8 1.8 1.8 1.8 0 0 0
406 1.8 1.8 0 0 0 0 1.8 1.8 1.8 1.8 1.8 1.8 0 1.8
407 0 1.8 1.8 1.8 0 0 1.8 1.8 1.8 1.8 1.8 1.8 0 0
408 0 0 1.8 0 0 0 1.8 1.8 1.8 1.8 1.8 1.8 0 0
409 0 0 1.8 1.8 0 1.8 1.8 1.8 1.8 1.8 1.8 1.8 0 0
410 0 0 1.8 1.8 0 0 1.8 0 1.8 1.8 1.8 1.8 0 0
411 0 0 1.8 1.8 0 0 1.8 1.8 1.8 0 1.8 1.8 0 0
412 0 0 1.8 1.8 0 0 1.8 1.8 1.8 1.8 1.8 0 0 0
413 0 0 1.8 1.8 0 0 1.8 1.8 1.8 1.8 1.8 1.8 0 1.8
414 1.8 0 1.8 1.8 0 0 1.8 1.8 1.8 1.8 1.8 1.8 0 0
415 1.8 1.8 1.8 0 0 0 1.8 1.8 1.8 1.8 1.8 1.8 0 0
416 1.8 1.8 1.8 1.8 0 1.8 1.8 1.8 1.8 1.8 1.8 1.8 0 0
417 1.8 1.8 1.8 1.8 0 0 1.8 0 1.8 1.8 1.8 1.8 0 0
418 1.8 1.8 1.8 1.8 0 0 1.8 1.8 1.8 0 1.8 1.8 0 0
419 1.8 1.8 1.8 1.8 0 0 1.8 1.8 1.8 1.8 1.8 0 0 0
420 1.8 1.8 1.8 1.8 0 0 1.8 1.8 1.8 1.8 1.8 1.8 0 1.8
421 0 1.8 0 0 1.8 1.8 1.8 1.8 1.8 1.8 1.8 1.8 0 0
422 0 0 0 1.8 1.8 1.8 1.8 1.8 1.8 1.8 1.8 1.8 0 0
423 0 0 0 0 1.8 0 1.8 1.8 1.8 1.8 1.8 1.8 0 0
424 0 0 0 0 1.8 1.8 1.8 0 1.8 1.8 1.8 1.8 0 0
425 0 0 0 0 1.8 1.8 1.8 1.8 1.8 0 1.8 1.8 0 0
426 0 0 0 0 1.8 1.8 1.8 1.8 1.8 1.8 1.8 0 0 0
427 0 0 0 0 1.8 1.8 1.8 1.8 1.8 1.8 1.8 1.8 0 1.8
428 1.8 0 0 0 1.8 1.8 1.8 1.8 1.8 1.8 1.8 1.8 0 0
429 1.8 1.8 0 1.8 1.8 1.8 1.8 1.8 1.8 1.8 1.8 1.8 0 0
430 1.8 1.8 0 0 1.8 0 1.8 1.8 1.8 1.8 1.8 1.8 0 0
431 1.8 1.8 0 0 1.8 1.8 1.8 0 1.8 1.8 1.8 1.8 0 0
432 1.8 1.8 0 0 1.8 1.8 1.8 1.8 1.8 0 1.8 1.8 0 0
433 1.8 1.8 0 0 1.8 1.8 1.8 1.8 1.8 1.8 1.8 0 0 0
434 1.8 1.8 0 0 1.8 1.8 1.8 1.8 1.8 1.8 1.8 1.8 0 1.8
435 0 1.8 1.8 1.8 1.8 1.8 1.8 1.8 1.8 1.8 1.8 1.8 0 0
436 0 0 1.8 0 1.8 1.8 1.8 1.8 1.8 1.8 1.8 1.8 0 0
437 0 0 1.8 1.8 1.8 0 1.8 1.8 1.8 1.8 1.8 1.8 0 0
438 0 0 1.8 1.8 1.8 1.8 1.8 0 1.8 1.8 1.8 1.8 0 0
439 0 0 1.8 1.8 1.8 1.8 1.8 1.8 1.8 0 1.8 1.8 0 0
440 0 0 1.8 1.8 1.8 1.8 1.8 1.8 1.8 1.8 1.8 0 0 0
441 0 0 1.8 1.8 1.8 1.8 1.8 1.8 1.8 1.8 1.8 1.8 0 1.8
442 1.8 0 1.8 1.8 1.8 1.8 1.8 1.8 1.8 1.8 1.8 1.8 0 0
443 1.8 1.8 1.8 0 1.8 1.8 1.8 1.8 1.8 1.8 1.8 1.8 0 0
444 1.8 1.8 1.8 1.8 1.8 0 1.8 1.8 1.8 1.8 1.8 1.8 0 0
445 1.8 1.8 1.8 1.8 1.8 1.8 1.8 0 1.8 1.8 1.8 1.8 0 0
446 1.8 1.8 1.8 1.8 1.8 1.8 1.8 1.8 1.8 0 1.8 1.8 0 0
447 1.8 1.8 1.8 1.8 1.8 1.8 1.8 1.8 1.8 1.8 1.8 0 0 0
448 1.8 1.8 1.8 1.8 1.8 1.8 1.8 1.8 1.8 1.8 1.8 1.8 0 1.8
449 0 1.8 0 0 0 0 0 0 0 0 0 0 1.8 1.8
450 0 0 0 1.8 0 0 0 0 0 0 0 0 1.8 1.8
451 0 0 0 0 0 1.8 0 0 0 0 0 0 1.8 1.8
452 0 0 0 0 0 0 0 1.8 0 0 0 0 1.8 1.8
453 0 0 0 0 0 0 0 0 0 1.8 0 0 1.8 1.8
454 0 0 0 0 0 0 0 0 0 0 0 1.8 1.8 1.8
455 0 0 0 0 0 0 0 0 0 0 0 0 1.8 0
456 1.8 0 0 0 0 0 0 0 0 0 0 0 1.8 1.8
457 1.8 1.8 0 1.8 0 0 0 0 0 0 0 0 1.8 1.8
458 1.8 1.8 0 0 0 1.8 0 0 0 0 0 0 1.8 1.8
459 1.8 1.8 0 0 0 0 0 1.8 0 0 0 0 1.8 1.8
460 1.8 1.8 0 0 0 0 0 0 0 1.8 0 0 1.8 1.8
461 1.8 1.8 0 0 0 0 0 0 0 0 0 1.8 1.8 1.8
462 1.8 1.8 0 0 0 0 0 0 0 0 0 0 1.8 0
463 0 1.8 1.8 1.8 0 0 0 0 0 0 0 0 1.8 1.8
464 0 0 1.8 0 0 0 0 0 0 0 0 0 1.8 1.8
465 0 0 1.8 1.8 0 1.8 0 0 0 0 0 0 1.8 1.8
466 0 0 1.8 1.8 0 0 0 1.8 0 0 0 0 1.8 1.8
467 0 0 1.8 1.8 0 0 0 0 0 1.8 0 0 1.8 1.8
468 0 0 1.8 1.8 0 0 0 0 0 0 0 1.8 1.8 1.8
469 0 0 1.8 1.8 0 0 0 0 0 0 0 0 1.8 0
470 1.8 0 1.8 1.8 0 0 0 0 0 0 0 0 1.8 1.8
471 1.8 1.8 1.8 0 0 0 0 0 0 0 0 0 1.8 1.8
472 1.8 1.8 1.8 1.8 0 1.8 0 0 0 0 0 0 1.8 1.8
473 1.8 1.8 1.8 1.8 0 0 0 1.8 0 0 0 0 1.8 1.8
474 1.8 1.8 1.8 1.8 0 0 0 0 0 1.8 0 0 1.8 1.8
475 1.8 1.8 1.8 1.8 0 0 0 0 0 0 0 1.8 1.8 1.8
476 1.8 1.8 1.8 1.8 0 0 0 0 0 0 0 0 1.8 0
477 0 1.8 0 0 1.8 1.8 0 0 0 0 0 0 1.8 1.8
478 0 0 0 1.8 1.8 1.8 0 0 0 0 0 0 1.8 1.8
479 0 0 0 0 1.8 0 0 0 0 0 0 0 1.8 1.8
480 0 0 0 0 1.8 1.8 0 1.8 0 0 0 0 1.8 1.8
481 0 0 0 0 1.8 1.8 0 0 0 1.8 0 0 1.8 1.8
482 0 0 0 0 1.8 1.8 0 0 0 0 0 1.8 1.8 1.8
483 0 0 0 0 1.8 1.8 0 0 0 0 0 0 1.8 0
484 1.8 0 0 0 1.8 1.8 0 0 0 0 0 0 1.8 1.8
485 1.8 1.8 0 1.8 1.8 1.8 0 0 0 0 0 0 1.8 1.8
486 1.8 1.8 0 0 1.8 0 0 0 0 0 0 0 1.8 1.8
487 1.8 1.8 0 0 1.8 1.8 0 1.8 0 0 0 0 1.8 1.8
488 1.8 1.8 0 0 1.8 1.8 0 0 0 1.8 0 0 1.8 1.8
489 1.8 1.8 0 0 1.8 1.8 0 0 0 0 0 1.8 1.8 1.8
490 1.8 1.8 0 0 1.8 1.8 0 0 0 0 0 0 1.8 0
491 0 1.8 1.8 1.8 1.8 1.8 0 0 0 0 0 0 1.8 1.8
492 0 0 1.8 0 1.8 1.8 0 0 0 0 0 0 1.8 1.8
493 0 0 1.8 1.8 1.8 0 0 0 0 0 0 0 1.8 1.8
494 0 0 1.8 1.8 1.8 1.8 0 1.8 0 0 0 0 1.8 1.8
495 0 0 1.8 1.8 1.8 1.8 0 0 0 1.8 0 0 1.8 1.8
496 0 0 1.8 1.8 1.8 1.8 0 0 0 0 0 1.8 1.8 1.8
497 0 0 1.8 1.8 1.8 1.8 0 0 0 0 0 0 1.8 0
498 1.8 0 1.8 1.8 1.8 1.8 0 0 0 0 0 0 1.8 1.8
499 1.8 1.8 1.8 0 1.8 1.8 0 0 0 0 0 0 1.8 1.8
500 1.8 1.8 1.8 1.8 1.8 0 0 0 0 0 0 0 1.8 1.8
501 1.8 1.8 1.8 1.8 1.8 1.8 0 1.8 0 0 0 0 1.8 1.8
502 1.8 1.8 1.8 1.8 1.8 1.8 0 0 0 1.8 0 0 1.8 1.8
503 1.8 1.8 1.8 1.8 1.8 1.8 0 0 0 0 0 1.8 1.8 1.8
504 1.8 1.8 1.8 1.8 1.8 1.8 0 0 0 0 0 0 1.8 0
505 0 1.8 0 0 0 0 1.8 1.8 0 0 0 0 1.8 1.8
506 0 0 0 1.8 0 0 1.8 1.8 0 0 0 0 1.8 1.8
507 0 0 0 0 0 1.8 1.8 1.8 0 0 0 0 1.8 1.8
508 0 0 0 0 0 0 1.8 0 0 0 0 0 1.8 1.8
509 0 0 0 0 0 0 1.8 1.8 0 1.8 0 0 1.8 1.8
510 0 0 0 0 0 0 1.8 1.8 0 0 0 1.8 1.8 1.8
511 0 0 0 0 0 0 1.8 1.8 0 0 0 0 1.8 0
512 1.8 0 0 0 0 0 1.8 1.8 0 0 0 0 1.8 1.8
513 1.8 1.8 0 1.8 0 0 1.8 1.8 0 0 0 0 1.8 1.8
514 1.8 1.8 0 0 0 1.8 1.8 1.8 0 0 0 0 1.8 1.8
515 1.8 1.8 0 0 0 0 1.8 0 0 0 0 0 1.8 1.8
516 1.8 1.8 0 0 0 0 1.8 1.8 0 1.8 0 0 1.8 1.8
517 1.8 1.8 0 0 0 0 1.8 1.8 0 0 0 1.8 1.8 1.8
518 1.8 1.8 0 0 0 0 1.8 1.8 0 0 0 0 1.8 0
519 0 1.8 1.8 1.8 0 0 1.8 1.8 0 0 0 0 1.8 1.8
520 0 0 1.8 0 0 0 1.8 1.8 0 0 0 0 1.8 1.8
521 0 0 1.8 1.8 0 1.8 1.8 1.8 0 0 0 0 1.8 1.8
522 0 0 1.8 1.8 0 0 1.8 0 0 0 0 0 1.8 1.8
523 0 0 1.8 1.8 0 0 1.8 1.8 0 1.8 0 0 1.8 1.8
524 0 0 1.8 1.8 0 0 1.8 1.8 0 0 0 1.8 1.8 1.8
525 0 0 1.8 1.8 0 0 1.8 1.8 0 0 0 0 1.8 0
526 1.8 0 1.8 1.8 0 0 1.8 1.8 0 0 0 0 1.8 1.8
527 1.8 1.8 1.8 0 0 0 1.8 1.8 0 0 0 0 1.8 1.8
528 1.8 1.8 1.8 1.8 0 1.8 1.8 1.8 0 0 0 0 1.8 1.8
529 1.8 1.8 1.8 1.8 0 0 1.8 0 0 0 0 0 1.8 1.8
530 1.8 1.8 1.8 1.8 0 0 1.8 1.8 0 1.8 0 0 1.8 1.8
531 1.8 1.8 1.8 1.8 0 0 1.8 1.8 0 0 0 1.8 1.8 1.8
532 1.8 1.8 1.8 1.8 0 0 1.8 1.8 0 0 0 0 1.8 0
533 0 1.8 0 0 1.8 1.8 1.8 1.8 0 0 0 0 1.8 1.8
534 0 0 0 1.8 1.8 1.8 1.8 1.8 0 0 0 0 1.8 1.8
535 0 0 0 0 1.8 0 1.8 1.8 0 0 0 0 1.8 1.8
536 0 0 0 0 1.8 1.8 1.8 0 0 0 0 0 1.8 1.8
537 0 0 0 0 1.8 1.8 1.8 1.8 0 1.8 0 0 1.8 1.8
538 0 0 0 0 1.8 1.8 1.8 1.8 0 0 0 1.8 1.8 1.8
539 0 0 0 0 1.8 1.8 1.8 1.8 0 0 0 0 1.8 0
540 1.8 0 0 0 1.8 1.8 1.8 1.8 0 0 0 0 1.8 1.8
541 1.8 1.8 0 1.8 1.8 1.8 1.8 1.8 0 0 0 0 1.8 1.8
542 1.8 1.8 0 0 1.8 0 1.8 1.8 0 0 0 0 1.8 1.8
543 1.8 1.8 0 0 1.8 1.8 1.8 0 0 0 0 0 1.8 1.8
544 1.8 1.8 0 0 1.8 1.8 1.8 1.8 0 1.8 0 0 1.8 1.8
545 1.8 1.8 0 0 1.8 1.8 1.8 1.8 0 0 0 1.8 1.8 1.8
546 1.8 1.8 0 0 1.8 1.8 1.8 1.8 0 0 0 0 1.8 0
547 0 1.8 1.8 1.8 1.8 1.8 1.8 1.8 0 0 0 0 1.8 1.8
548 0 0 1.8 0 1.8 1.8 1.8 1.8 0 0 0 0 1.8 1.8
549 0 0 1.8 1.8 1.8 0 1.8 1.8 0 0 0 0 1.8 1.8
550 0 0 1.8 1.8 1.8 1.8 1.8 0 0 0 0 0 1.8 1.8
551 0 0 1.8 1.8 1.8 1.8 1.8 1.8 0 1.8 0 0 1.8 1.8
552 0 0 1.8 1.8 1.8 1.8 1.8 1.8 0 0 0 1.8 1.8 1.8
553 0 0 1.8 1.8 1.8 1.8 1.8 1.8 0 0 0 0 1.8 0
554 1.8 0 1.8 1.8 1.8 1.8 1.8 1.8 0 0 0 0 1.8 1.8
555 1.8 1.8 1.8 0 1.8 1.8 1.8 1.8 0 0 0 0 1.8 1.8
556 1.8 1.8 1.8 1.8 1.8 0 1.8 1.8 0 0 0 0 1.8 1.8
557 1.8 1.8 1.8 1.8 1.8 1.8 1.8 0 0 0 0 0 1.8 1.8
558 1.8 1.8 1.8 1.8 1.8 1.8 1.8 1.8 0 1.8 0 0 1.8 1.8
559 1.8 1.8 1.8 1.8 1.8 1.8 1.8 1.8 0 0 0 1.8 1.8 1.8
560 1.8 1.8 1.8 1.8 1.8 1.8 1.8 1.8 0 0 0 0 1.8 0
561 0 1.8 0 0 0 0 0 0 1.8 1.8 0 0 1.8 1.8
562 0 0 0 1.8 0 0 0 0 1.8 1.8 0 0 1.8 1.8
563 0 0 0 0 0 1.8 0 0 1.8 1.8 0 0 1.8 1.8
564 0 0 0 0 0 0 0 1.8 1.8 1.8 0 0 1.8 1.8
565 0 0 0 0 0 0 0 0 1.8 0 0 0 1.8 1.8
566 0 0 0 0 0 0 0 0 1.8 1.8 0 1.8 1.8 1.8
567 0 0 0 0 0 0 0 0 1.8 1.8 0 0 1.8 0
568 1.8 0 0 0 0 0 0 0 1.8 1.8 0 0 1.8 1.8
569 1.8 1.8 0 1.8 0 0 0 0 1.8 1.8 0 0 1.8 1.8
570 1.8 1.8 0 0 0 1.8 0 0 1.8 1.8 0 0 1.8 1.8
571 1.8 1.8 0 0 0 0 0 1.8 1.8 1.8 0 0 1.8 1.8
572 1.8 1.8 0 0 0 0 0 0 1.8 0 0 0 1.8 1.8
573 1.8 1.8 0 0 0 0 0 0 1.8 1.8 0 1.8 1.8 1.8
574 1.8 1.8 0 0 0 0 0 0 1.8 1.8 0 0 1.8 0
575 0 1.8 1.8 1.8 0 0 0 0 1.8 1.8 0 0 1.8 1.8
576 0 0 1.8 0 0 0 0 0 1.8 1.8 0 0 1.8 1.8
577 0 0 1.8 1.8 0 1.8 0 0 1.8 1.8 0 0 1.8 1.8
578 0 0 1.8 1.8 0 0 0 1.8 1.8 1.8 0 0 1.8 1.8
579 0 0 1.8 1.8 0 0 0 0 1.8 0 0 0 1.8 1.8
580 0 0 1.8 1.8 0 0 0 0 1.8 1.8 0 1.8 1.8 1.8
581 0 0 1.8 1.8 0 0 0 0 1.8 1.8 0 0 1.8 0
582 1.8 0 1.8 1.8 0 0 0 0 1.8 1.8 0 0 1.8 1.8
583 1.8 1.8 1.8 0 0 0 0 0 1.8 1.8 0 0 1.8 1.8
584 1.8 1.8 1.8 1.8 0 1.8 0 0 1.8 1.8 0 0 1.8 1.8
585 1.8 1.8 1.8 1.8 0 0 0 1.8 1.8 1.8 0 0 1.8 1.8
586 1.8 1.8 1.8 1.8 0 0 0 0 1.8 0 0 0 1.8 1.8
587 1.8 1.8 1.8 1.8 0 0 0 0 1.8 1.8 0 1.8 1.8 1.8
588 1.8 1.8 1.8 1.8 0 0 0 0 1.8 1.8 0 0 1.8 0
589 0 1.8 0 0 1.8 1.8 0 0 1.8 1.8 0 0 1.8 1.8
590 0 0 0 1.8 1.8 1.8 0 0 1.8 1.8 0 0 1.8 1.8
591 0 0 0 0 1.8 0 0 0 1.8 1.8 0 0 1.8 1.8
592 0 0 0 0 1.8 1.8 0 1.8 1.8 1.8 0 0 1.8 1.8
593 0 0 0 0 1.8 1.8 0 0 1.8 0 0 0 1.8 1.8
594 0 0 0 0 1.8 1.8 0 0 1.8 1.8 0 1.8 1.8 1.8
595 0 0 0 0 1.8 1.8 0 0 1.8 1.8 0 0 1.8 0
596 1.8 0 0 0 1.8 1.8 0 0 1.8 1.8 0 0 1.8 1.8
597 1.8 1.8 0 1.8 1.8 1.8 0 0 1.8 1.8 0 0 1.8 1.8
598 1.8 1.8 0 0 1.8 0 0 0 1.8 1.8 0 0 1.8 1.8
599 1.8 1.8 0 0 1.8 1.8 0 1.8 1.8 1.8 0 0 1.8 1.8
600 1.8 1.8 0 0 1.8 1.8 0 0 1.8 0 0 0 1.8 1.8
601 1.8 1.8 0 0 1.8 1.8 0 0 1.8 1.8 0 1.8 1.8 1.8
602 1.8 1.8 0 0 1.8 1.8 0 0 1.8 1.8 0 0 1.8 0
603 0 1.8 1.8 1.8 1.8 1.8 0 0 1.8 1.8 0 0 1.8 1.8
604 0 0 1.8 0 1.8 1.8 0 0 1.8 1.8 0 0 1.8 1.8
605 0 0 1.8 1.8 1.8 0 0 0 1.8 1.8 0 0 1.8 1.8
606 0 0 1.8 1.8 1.8 1.8 0 1.8 1.8 1.8 0 0 1.8 1.8
607 0 0 1.8 1.8 1.8 1.8 0 0 1.8 0 0 0 1.8 1.8
608 0 0 1.8 1.8 1.8 1.8 0 0 1.8 1.8 0 1.8 1.8 1.8
609 0 0 1.8 1.8 1.8 1.8 0 0 1.8 1.8 0 0 1.8 0
610 1.8 0 1.8 1.8 1.8 1.8 0 0 1.8 1.8 0 0 1.8 1.8
611 1.8 1.8 1.8 0 1.8 1.8 0 0 1.8 1.8 0 0 1.8 1.8
612 1.8 1.8 1.8 1.8 1.8 0 0 0 1.8 1.8 0 0 1.8 1.8
613 1.8 1.8 1.8 1.8 1.8 1.8 0 1.8 1.8 1.8 0 0 1.8 1.8
614 1.8 1.8 1.8 1.8 1.8 1.8 0 0 1.8 0 0 0 1.8 1.8
615 1.8 1.8 1.8 1.8 1.8 1.8 0 0 1.8 1.8 0 1.8 1.8 1.8
616 1.8 1.8 1.8 1.8 1.8 1.8 0 0 1.8 1.8 0 0 1.8 0
617 0 1.8 0 0 0 0 1.8 1.8 1.8 1.8 0 0 1.8 1.8
618 0 0 0 1.8 0 0 1.8 1.8 1.8 1.8 0 0 1.8 1.8
619 0 0 0 0 0 1.8 1.8 1.8 1.8 1.8 0 0 1.8 1.8
620 0 0 0 0 0 0 1.8 0 1.8 1.8 0 0 1.8 1.8
621 0 0 0 0 0 0 1.8 1.8 1.8 0 0 0 1.8 1.8
622 0 0 0 0 0 0 1.8 1.8 1.8 1.8 0 1.8 1.8 1.8
623 0 0 0 0 0 0 1.8 1.8 1.8 1.8 0 0 1.8 0
624 1.8 0 0 0 0 0 1.8 1.8 1.8 1.8 0 0 1.8 1.8
625 1.8 1.8 0 1.8 0 0 1.8 1.8 1.8 1.8 0 0 1.8 1.8
626 1.8 1.8 0 0 0 1.8 1.8 1.8 1.8 1.8 0 0 1.8 1.8
627 1.8 1.8 0 0 0 0 1.8 0 1.8 1.8 0 0 1.8 1.8
628 1.8 1.8 0 0 0 0 1.8 1.8 1.8 0 0 0 1.8 1.8
629 1.8 1.8 0 0 0 0 1.8 1.8 1.8 1.8 0 1.8 1.8 1.8
630 1.8 1.8 0 0 0 0 1.8 1.8 1.8 1.8 0 0 1.8 0
631 0 1.8 1.8 1.8 0 0 1.8 1.8 1.8 1.8 0 0 1.8 1.8
632 0 0 1.8 0 0 0 1.8 1.8 1.8 1.8 0 0 1.8 1.8
633 0 0 1.8 1.8 0 1.8 1.8 1.8 1.8 1.8 0 0 1.8 1.8
634 0 0 1.8 1.8 0 0 1.8 0 1.8 1.8 0 0 1.8 1.8
635 0 0 1.8 1.8 0 0 1.8 1.8 1.8 0 0 0 1.8 1.8
636 0 0 1.8 1.8 0 0 1.8 1.8 1.8 1.8 0 1.8 1.8 1.8
637 0 0 1.8 1.8 0 0 1.8 1.8 1.8 1.8 0 0 1.8 0
638 1.8 0 1.8 1.8 0 0 1.8 1.8 1.8 1.8 0 0 1.8 1.8
639 1.8 1.8 1.8 0 0 0 1.8 1.8 1.8 1.8 0 0 1.8 1.8
640 1.8 1.8 1.8 1.8 0 1.8 1.8 1.8 1.8 1.8 0 0 1.8 1.8
641 1.8 1.8 1.8 1.8 0 0 1.8 0 1.8 1.8 0 0 1.8 1.8
642 1.8 1.8 1.8 1.8 0 0 1.8 1.8 1.8 0 0 0 1.8 1.8
643 1.8 1.8 1.8 1.8 0 0 1.8 1.8 1.8 1.8 0 1.8 1.8 1.8
644 1.8 1.8 1.8 1.8 0 0 1.8 1.8 1.8 1.8 0 0 1.8 0
645 0 1.8 0 0 1.8 1.8 1.8 1.8 1.8 1.8 0 0 1.8 1.8
646 0 0 0 1.8 1.8 1.8 1.8 1.8 1.8 1.8 0 0 1.8 1.8
647 0 0 0 0 1.8 0 1.8 1.8 1.8 1.8 0 0 1.8 1.8
648 0 0 0 0 1.8 1.8 1.8 0 1.8 1.8 0 0 1.8 1.8
649 0 0 0 0 1.8 1.8 1.8 1.8 1.8 0 0 0 1.8 1.8
650 0 0 0 0 1.8 1.8 1.8 1.8 1.8 1.8 0 1.8 1.8 1.8
651 0 0 0 0 1.8 1.8 1.8 1.8 1.8 1.8 0 0 1.8 0
652 1.8 0 0 0 1.8 1.8 1.8 1.8 1.8 1.8 0 0 1.8 1.8
653 1.8 1.8 0 1.8 1.8 1.8 1.8 1.8 1.8 1.8 0 0 1.8 1.8
654 1.8 1.8 0 0 1.8 0 1.8 1.8 1.8 1.8 0 0 1.8 1.8
655 1.8 1.8 0 0 1.8 1.8 1.8 0 1.8 1.8 0 0 1.8 1.8
656 1.8 1.8 0 0 1.8 1.8 1.8 1.8 1.8 0 0 0 1.8 1.8
657 1.8 1.8 0 0 1.8 1.8 1.8 1.8 1.8 1.8 0 1.8 1.8 1.8
658 1.8 1.8 0 0 1.8 1.8 1.8 1.8 1.8 1.8 0 0 1.8 0
659 0 1.8 1.8 1.8 1.8 1.8 1.8 1.8 1.8 1.8 0 0 1.8 1.8
660 0 0 1.8 0 1.8 1.8 1.8 1.8 1.8 1.8 0 0 1.8 1.8
661 0 0 1.8 1.8 1.8 0 1.8 1.8 1.8 1.8 0 0 1.8 1.8
662 0 0 1.8 1.8 1.8 1.8 1.8 0 1.8 1.8 0 0 1.8 1.8
663 0 0 1.8 1.8 1.8 1.8 1.8 1.8 1.8 0 0 0 1.8 1.8
664 0 0 1.8 1.8 1.8 1.8 1.8 1.8 1.8 1.8 0 1.8 1.8 1.8
665 0 0 1.8 1.8 1.8 1.8 1.8 1.8 1.8 1.8 0 0 1.8 0
666 1.8 0 1.8 1.8 1.8 1.8 1.8 1.8 1.8 1.8 0 0 1.8 1.8
667 1.8 1.8 1.8 0 1.8 1.8 1.8 1.8 1.8 1.8 0 0 1.8 1.8
668 1.8 1.8 1.8 1.8 1.8 0 1.8 1.8 1.8 1.8 0 0 1.8 1.8
669 1.8 1.8 1.8 1.8 1.8 1.8 1.8 0 1.8 1.8 0 0 1.8 1.8
670 1.8 1.8 1.8 1.8 1.8 1.8 1.8 1.8 1.8 0 0 0 1.8 1.8
671 1.8 1.8 1.8 1.8 1.8 1.8 1.8 1.8 1.8 1.8 0 1.8 1.8 1.8
672 1.8 1.8 1.8 1.8 1.8 1.8 1.8 1.8 1.8 1.8 0 0 1.8 0
673 0 1.8 0 0 0 0 0 0 0 0 1.8 1.8 1.8 1.8
674 0 0 0 1.8 0 0 0 0 0 0 1.8 1.8 1.8 1.8
675 0 0 0 0 0 1.8 0 0 0 0 1.8 1.8 1.8 1.8
676 0 0 0 0 0 0 0 1.8 0 0 1.8 1.8 1.8 1.8
677 0 0 0 0 0 0 0 0 0 1.8 1.8 1.8 1.8 1.8
678 0 0 0 0 0 0 0 0 0 0 1.8 0 1.8 1.8
679 0 0 0 0 0 0 0 0 0 0 1.8 1.8 1.8 0
680 1.8 0 0 0 0 0 0 0 0 0 1.8 1.8 1.8 1.8
681 1.8 1.8 0 1.8 0 0 0 0 0 0 1.8 1.8 1.8 1.8
682 1.8 1.8 0 0 0 1.8 0 0 0 0 1.8 1.8 1.8 1.8
683 1.8 1.8 0 0 0 0 0 1.8 0 0 1.8 1.8 1.8 1.8
684 1.8 1.8 0 0 0 0 0 0 0 1.8 1.8 1.8 1.8 1.8
685 1.8 1.8 0 0 0 0 0 0 0 0 1.8 0 1.8 1.8
686 1.8 1.8 0 0 0 0 0 0 0 0 1.8 1.8 1.8 0
687 0 1.8 1.8 1.8 0 0 0 0 0 0 1.8 1.8 1.8 1.8
688 0 0 1.8 0 0 0 0 0 0 0 1.8 1.8 1.8 1.8
689 0 0 1.8 1.8 0 1.8 0 0 0 0 1.8 1.8 1.8 1.8
690 0 0 1.8 1.8 0 0 0 1.8 0 0 1.8 1.8 1.8 1.8
691 0 0 1.8 1.8 0 0 0 0 0 1.8 1.8 1.8 1.8 1.8
692 0 0 1.8 1.8 0 0 0 0 0 0 1.8 0 1.8 1.8
693 0 0 1.8 1.8 0 0 0 0 0 0 1.8 1.8 1.8 0
694 1.8 0 1.8 1.8 0 0 0 0 0 0 1.8 1.8 1.8 1.8
695 1.8 1.8 1.8 0 0 0 0 0 0 0 1.8 1.8 1.8 1.8
696 1.8 1.8 1.8 1.8 0 1.8 0 0 0 0 1.8 1.8 1.8 1.8
697 1.8 1.8 1.8 1.8 0 0 0 1.8 0 0 1.8 1.8 1.8 1.8
698 1.8 1.8 1.8 1.8 0 0 0 0 0 1.8 1.8 1.8 1.8 1.8
699 1.8 1.8 1.8 1.8 0 0 0 0 0 0 1.8 0 1.8 1.8
700 1.8 1.8 1.8 1.8 0 0 0 0 0 0 1.8 1.8 1.8 0
701 0 1.8 0 0 1.8 1.8 0 0 0 0 1.8 1.8 1.8 1.8
702 0 0 0 1.8 1.8 1.8 0 0 0 0 1.8 1.8 1.8 1.8
703 0 0 0 0 1.8 0 0 0 0 0 1.8 1.8 1.8 1.8
704 0 0 0 0 1.8 1.8 0 1.8 0 0 1.8 1.8 1.8 1.8
705 0 0 0 0 1.8 1.8 0 0 0 1.8 1.8 1.8 1.8 1.8
706 0 0 0 0 1.8 1.8 0 0 0 0 1.8 0 1.8 1.8
707 0 0 0 0 1.8 1.8 0 0 0 0 1.8 1.8 1.8 0
708 1.8 0 0 0 1.8 1.8 0 0 0 0 1.8 1.8 1.8 1.8
709 1.8 1.8 0 1.8 1.8 1.8 0 0 0 0 1.8 1.8 1.8 1.8
710 1.8 1.8 0 0 1.8 0 0 0 0 0 1.8 1.8 1.8 1.8
711 1.8 1.8 0 0 1.8 1.8 0 1.8 0 0 1.8 1.8 1.8 1.8
712 1.8 1.8 0 0 1.8 1.8 0 0 0 1.8 1.8 1.8 1.8 1.8
713 1.8 1.8 0 0 1.8 1.8 0 0 0 0 1.8 0 1.8 1.8
714 1.8 1.8 0 0 1.8 1.8 0 0 0 0 1.8 1.8 1.8 0
715 0 1.8 1.8 1.8 1.8 1.8 0 0 0 0 1.8 1.8 1.8 1.8
716 0 0 1.8 0 1.8 1.8 0 0 0 0 1.8 1.8 1.8 1.8
717 0 0 1.8 1.8 1.8 0 0 0 0 0 1.8 1.8 1.8 1.8
718 0 0 1.8 1.8 1.8 1.8 0 1.8 0 0 1.8 1.8 1.8 1.8
719 0 0 1.8 1.8 1.8 1.8 0 0 0 1.8 1.8 1.8 1.8 1.8
720 0 0 1.8 1.8 1.8 1.8 0 0 0 0 1.8 0 1.8 1.8
721 0 0 1.8 1.8 1.8 1.8 0 0 0 0 1.8 1.8 1.8 0
722 1.8 0 1.8 1.8 1.8 1.8 0 0 0 0 1.8 1.8 1.8 1.8
723 1.8 1.8 1.8 0 1.8 1.8 0 0 0 0 1.8 1.8 1.8 1.8
724 1.8 1.8 1.8 1.8 1.8 0 0 0 0 0 1.8 1.8 1.8 1.8
725 1.8 1.8 1.8 1.8 1.8 1.8 0 1.8 0 0 1.8 1.8 1.8 1.8
726 1.8 1.8 1.8 1.8 1.8 1.8 0 0 0 1.8 1.8 1.8 1.8 1.8
727 1.8 1.8 1.8 1.8 1.8 1.8 0 0 0 0 1.8 0 1.8 1.8
728 1.8 1.8 1.8 1.8 1.8 1.8 0 0 0 0 1.8 1.8 1.8 0
729 0 1.8 0 0 0 0 1.8 1.8 0 0 1.8 1.8 1.8 1.8
730 0 0 0 1.8 0 0 1.8 1.8 0 0 1.8 1.8 1.8 1.8
731 0 0 0 0 0 1.8 1.8 1.8 0 0 1.8 1.8 1.8 1.8
732 0 0 0 0 0 0 1.8 0 0 0 1.8 1.8 1.8 1.8
733 0 0 0 0 0 0 1.8 1.8 0 1.8 1.8 1.8 1.8 1.8
734 0 0 0 0 0 0 1.8 1.8 0 0 1.8 0 1.8 1.8
735 0 0 0 0 0 0 1.8 1.8 0 0 1.8 1.8 1.8 0
736 1.8 0 0 0 0 0 1.8 1.8 0 0 1.8 1.8 1.8 1.8
737 1.8 1.8 0 1.8 0 0 1.8 1.8 0 0 1.8 1.8 1.8 1.8
738 1.8 1.8 0 0 0 1.8 1.8 1.8 0 0 1.8 1.8 1.8 1.8
739 1.8 1.8 0 0 0 0 1.8 0 0 0 1.8 1.8 1.8 1.8
740 1.8 1.8 0 0 0 0 1.8 1.8 0 1.8 1.8 1.8 1.8 1.8
741 1.8 1.8 0 0 0 0 1.8 1.8 0 0 1.8 0 1.8 1.8
742 1.8 1.8 0 0 0 0 1.8 1.8 0 0 1.8 1.8 1.8 0
743 0 1.8 1.8 1.8 0 0 1.8 1.8 0 0 1.8 1.8 1.8 1.8
744 0 0 1.8 0 0 0 1.8 1.8 0 0 1.8 1.8 1.8 1.8
745 0 0 1.8 1.8 0 1.8 1.8 1.8 0 0 1.8 1.8 1.8 1.8
746 0 0 1.8 1.8 0 0 1.8 0 0 0 1.8 1.8 1.8 1.8
747 0 0 1.8 1.8 0 0 1.8 1.8 0 1.8 1.8 1.8 1.8 1.8
748 0 0 1.8 1.8 0 0 1.8 1.8 0 0 1.8 0 1.8 1.8
749 0 0 1.8 1.8 0 0 1.8 1.8 0 0 1.8 1.8 1.8 0
750 1.8 0 1.8 1.8 0 0 1.8 1.8 0 0 1.8 1.8 1.8 1.8
751 1.8 1.8 1.8 0 0 0 1.8 1.8 0 0 1.8 1.8 1.8 1.8
752 1.8 1.8 1.8 1.8 0 1.8 1.8 1.8 0 0 1.8 1.8 1.8 1.8
753 1.8 1.8 1.8 1.8 0 0 1.8 0 0 0 1.8 1.8 1.8 1.8
754 1.8 1.8 1.8 1.8 0 0 1.8 1.8 0 1.8 1.8 1.8 1.8 1.8
755 1.8 1.8 1.8 1.8 0 0 1.8 1.8 0 0 1.8 0 1.8 1.8
756 1.8 1.8 1.8 1.8 0 0 1.8 1.8 0 0 1.8 1.8 1.8 0
757 0 1.8 0 0 1.8 1.8 1.8 1.8 0 0 1.8 1.8 1.8 1.8
758 0 0 0 1.8 1.8 1.8 1.8 1.8 0 0 1.8 1.8 1.8 1.8
759 0 0 0 0 1.8 0 1.8 1.8 0 0 1.8 1.8 1.8 1.8
760 0 0 0 0 1.8 1.8 1.8 0 0 0 1.8 1.8 1.8 1.8
761 0 0 0 0 1.8 1.8 1.8 1.8 0 1.8 1.8 1.8 1.8 1.8
762 0 0 0 0 1.8 1.8 1.8 1.8 0 0 1.8 0 1.8 1.8
763 0 0 0 0 1.8 1.8 1.8 1.8 0 0 1.8 1.8 1.8 0
764 1.8 0 0 0 1.8 1.8 1.8 1.8 0 0 1.8 1.8 1.8 1.8
765 1.8 1.8 0 1.8 1.8 1.8 1.8 1.8 0 0 1.8 1.8 1.8 1.8
766 1.8 1.8 0 0 1.8 0 1.8 1.8 0 0 1.8 1.8 1.8 1.8
767 1.8 1.8 0 0 1.8 1.8 1.8 0 0 0 1.8 1.8 1.8 1.8
768 1.8 1.8 0 0 1.8 1.8 1.8 1.8 0 1.8 1.8 1.8 1.8 1.8
769 1.8 1.8 0 0 1.8 1.8 1.8 1.8 0 0 1.8 0 1.8 1.8
770 1.8 1.8 0 0 1.8 1.8 1.8 1.8 0 0 1.8 1.8 1.8 0
771 0 1.8 1.8 1.8 1.8 1.8 1.8 1.8 0 0 1.8 1.8 1.8 1.8
772 0 0 1.8 0 1.8 1.8 1.8 1.8 0 0 1.8 1.8 1.8 1.8
773 0 0 1.8 1.8 1.8 0 1.8 1.8 0 0 1.8 1.8 1.8 1.8
774 0 0 1.8 1.8 1.8 1.8 1.8 0 0 0 1.8 1.8 1.8 1.8
775 0 0 1.8 1.8 1.8 1.8 1.8 1.8 0 1.8 1.8 1.8 1.8 1.8
776 0 0 1.8 1.8 1.8 1.8 1.8 1.8 0 0 1.8 0 1.8 1.8
777 0 0 1.8 1.8 1.8 1.8 1.8 1.8 0 0 1.8 1.8 1.8 0
778 1.8 0 1.8 1.8 1.8 1.8 1.8 1.8 0 0 1.8 1.8 1.8 1.8
779 1.8 1.8 1.8 0 1.8 1.8 1.8 1.8 0 0 1.8 1.8 1.8 1.8
780 1.8 1.8 1.8 1.8 1.8 0 1.8 1.8 0 0 1.8 1.8 1.8 1.8
781 1.8 1.8 1.8 1.8 1.8 1.8 1.8 0 0 0 1.8 1.8 1.8 1.8
782 1.8 1.8 1.8 1.8 1.8 1.8 1.8 1.8 0 1.8 1.8 1.8 1.8 1.8
783 1.8 1.8 1.8 1.8 1.8 1.8 1.8 1.8 0 0 1.8 0 1.8 1.8
784 1.8 1.8 1.8 1.8 1.8 1.8 1.8 1.8 0 0 1.8 1.8 1.8 0
785 0 1.8 0 0 0 0 0 0 1.8 1.8 1.8 1.8 1.8 1.8
786 0 0 0 1.8 0 0 0 0 1.8 1.8 1.8 1.8 1.8 1.8
787 0 0 0 0 0 1.8 0 0 1.8 1.8 1.8 1.8 1.8 1.8
788 0 0 0 0 0 0 0 1.8 1.8 1.8 1.8 1.8 1.8 1.8
789 0 0 0 0 0 0 0 0 1.8 0 1.8 1.8 1.8 1.8
790 0 0 0 0 0 0 0 0 1.8 1.8 1.8 0 1.8 1.8
791 0 0 0 0 0 0 0 0 1.8 1.8 1.8 1.8 1.8 0
792 1.8 0 0 0 0 0 0 0 1.8 1.8 1.8 1.8 1.8 1.8
793 1.8 1.8 0 1.8 0 0 0 0 1.8 1.8 1.8 1.8 1.8 1.8
794 1.8 1.8 0 0 0 1.8 0 0 1.8 1.8 1.8 1.8 1.8 1.8
795 1.8 1.8 0 0 0 0 0 1.8 1.8 1.8 1.8 1.8 1.8 1.8
796 1.8 1.8 0 0 0 0 0 0 1.8 0 1.8 1.8 1.8 1.8
797 1.8 1.8 0 0 0 0 0 0 1.8 1.8 1.8 0 1.8 1.8
798 1.8 1.8 0 0 0 0 0 0 1.8 1.8 1.8 1.8 1.8 0
799 0 1.8 1.8 1.8 0 0 0 0 1.8 1.8 1.8 1.8 1.8 1.8
800 0 0 1.8 0 0 0 0 0 1.8 1.8 1.8 1.8 1.8 1.8
801 0 0 1.8 1.8 0 1.8 0 0 1.8 1.8 1.8 1.8 1.8 1.8
802 0 0 1.8 1.8 0 0 0 1.8 1.8 1.8 1.8 1.8 1.8 1.8
803 0 0 1.8 1.8 0 0 0 0 1.8 0 1.8 1.8 1.8 1.8
804 0 0 1.8 1.8 0 0 0 0 1.8 1.8 1.8 0 1.8 1.8
805 0 0 1.8 1.8 0 0 0 0 1.8 1.8 1.8 1.8 1.8 0
806 1.8 0 1.8 1.8 0 0 0 0 1.8 1.8 1.8 1.8 1.8 1.8
807 1.8 1.8 1.8 0 0 0 0 0 1.8 1.8 1.8 1.8 1.8 1.8
808 1.8 1.8 1.8 1.8 0 1.8 0 0 1.8 1.8 1.8 1.8 1.8 1.8
809 1.8 1.8 1.8 1.8 0 0 0 1.8 1.8 1.8 1.8 1.8 1.8 1.8
810 1.8 1.8 1.8 1.8 0 0 0 0 1.8 0 1.8 1.8 1.8 1.8
811 1.8 1.8 1.8 1.8 0 0 0 0 1.8 1.8 1.8 0 1.8 1.8
812 1.8 1.8 1.8 1.8 0 0 0 0 1.8 1.8 1.8 1.8 1.8 0
813 0 1.8 0 0 1.8 1.8 0 0 1.8 1.8 1.8 1.8 1.8 1.8
814 0 0 0 1.8 1.8 1.8 0 0 1.8 1.8 1.8 1.8 1.8 1.8
815 0 0 0 0 1.8 0 0 0 1.8 1.8 1.8 1.8 1.8 1.8
816 0 0 0 0 1.8 1.8 0 1.8 1.8 1.8 1.8 1.8 1.8 1.8
817 0 0 0 0 1.8 1.8 0 0 1.8 0 1.8 1.8 1.8 1.8
818 0 0 0 0 1.8 1.8 0 0 1.8 1.8 1.8 0 1.8 1.8
819 0 0 0 0 1.8 1.8 0 0 1.8 1.8 1.8 1.8 1.8 0
820 1.8 0 0 0 1.8 1.8 0 0 1.8 1.8 1.8 1.8 1.8 1.8
821 1.8 1.8 0 1.8 1.8 1.8 0 0 1.8 1.8 1.8 1.8 1.8 1.8
822 1.8 1.8 0 0 1.8 0 0 0 1.8 1.8 1.8 1.8 1.8 1.8
823 1.8 1.8 0 0 1.8 1.8 0 1.8 1.8 1.8 1.8 1.8 1.8 1.8
824 1.8 1.8 0 0 1.8 1.8 0 0 1.8 0 1.8 1.8 1.8 1.8
825 1.8 1.8 0 0 1.8 1.8 0 0 1.8 1.8 1.8 0 1.8 1.8
826 1.8 1.8 0 0 1.8 1.8 0 0 1.8 1.8 1.8 1.8 1.8 0
827 0 1.8 1.8 1.8 1.8 1.8 0 0 1.8 1.8 1.8 1.8 1.8 1.8
828 0 0 1.8 0 1.8 1.8 0 0 1.8 1.8 1.8 1.8 1.8 1.8
829 0 0 1.8 1.8 1.8 0 0 0 1.8 1.8 1.8 1.8 1.8 1.8
830 0 0 1.8 1.8 1.8 1.8 0 1.8 1.8 1.8 1.8 1.8 1.8 1.8
831 0 0 1.8 1.8 1.8 1.8 0 0 1.8 0 1.8 1.8 1.8 1.8
832 0 0 1.8 1.8 1.8 1.8 0 0 1.8 1.8 1.8 0 1.8 1.8
833 0 0 1.8 1.8 1.8 1.8 0 0 1.8 1.8 1.8 1.8 1.8 0
834 1.8 0 1.8 1.8 1.8 1.8 0 0 1.8 1.8 1.8 1.8 1.8 1.8
835 1.8 1.8 1.8 0 1.8 1.8 0 0 1.8 1.8 1.8 1.8 1.8 1.8
836 1.8 1.8 1.8 1.8 1.8 0 0 0 1.8 1.8 1.8 1.8 1.8 1.8
837 1.8 1.8 1.8 1.8 1.8 1.8 0 1.8 1.8 1.8 1.8 1.8 1.8 1.8
838 1.8 1.8 1.8 1.8 1.8 1.8 0 0 1.8 0 1.8 1.8 1.8 1.8
839 1.8 1.8 1.8 1.8 1.8 1.8 0 0 1.8 1.8 1.8 0 1.8 1.8
840 1.8 1.8 1.8 1.8 1.8 1.8 0 0 1.8 1.8 1.8 1.8 1.8 0
841 0 1.8 0 0 0 0 1.8 1.8 1.8 1.8 1.8 1.8 1.8 1.8
842 0 0 0 1.8 0 0 1.8 1.8 1.8 1.8 1.8 1.8 1.8 1.8
843 0 0 0 0 0 1.8 1.8 1.8 1.8 1.8 1.8 1.8 1.8 1.8
844 0 0 0 0 0 0 1.8 0 1.8 1.8 1.8 1.8 1.8 1.8
845 0 0 0 0 0 0 1.8 1.8 1.8 0 1.8 1.8 1.8 1.8
846 0 0 0 0 0 0 1.8 1.8 1.8 1.8 1.8 0 1.8 1.8
847 0 0 0 0 0 0 1.8 1.8 1.8 1.8 1.8 1.8 1.8 0
848 1.8 0 0 0 0 0 1.8 1.8 1.8 1.8 1.8 1.8 1.8 1.8
849 1.8 1.8 0 1.8 0 0 1.8 1.8 1.8 1.8 1.8 1.8 1.8 1.8
850 1.8 1.8 0 0 0 1.8 1.8 1.8 1.8 1.8 1.8 1.8 1.8 1.8
851 1.8 1.8 0 0 0 0 1.8 0 1.8 1.8 1.8 1.8 1.8 1.8
852 1.8 1.8 0 0 0 0 1.8 1.8 1.8 0 1.8 1.8 1.8 1.8
853 1.8 1.8 0 0 0 0 1.8 1.8 1.8 1.8 1.8 0 1.8 1.8
854 1.8 1.8 0 0 0 0 1.8 1.8 1.8 1.8 1.8 1.8 1.8 0
855 0 1.8 1.8 1.8 0 0 1.8 1.8 1.8 1.8 1.8 1.8 1.8 1.8
856 0 0 1.8 0 0 0 1.8 1.8 1.8 1.8 1.8 1.8 1.8 1.8
857 0 0 1.8 1.8 0 1.8 1.8 1.8 1.8 1.8 1.8 1.8 1.8 1.8
858 0 0 1.8 1.8 0 0 1.8 0 1.8 1.8 1.8 1.8 1.8 1.8
859 0 0 1.8 1.8 0 0 1.8 1.8 1.8 0 1.8 1.8 1.8 1.8
860 0 0 1.8 1.8 0 0 1.8 1.8 1.8 1.8 1.8 0 1.8 1.8
861 0 0 1.8 1.8 0 0 1.8 1.8 1.8 1.8 1.8 1.8 1.8 0
862 1.8 0 1.8 1.8 0 0 1.8 1.8 1.8 1.8 1.8 1.8 1.8 1.8
863 1.8 1.8 1.8 0 0 0 1.8 1.8 1.8 1.8 1.8 1.8 1.8 1.8
864 1.8 1.8 1.8 1.8 0 1.8 1.8 1.8 1.8 1.8 1.8 1.8 1.8 1.8
865 1.8 1.8 1.8 1.8 0 0 1.8 0 1.8 1.8 1.8 1.8 1.8 1.8
866 1.8 1.8 1.8 1.8 0 0 1.8 1.8 1.8 0 1.8 1.8 1.8 1.8
867 1.8 1.8 1.8 1.8 0 0 1.8 1.8 1.8 1.8 1.8 0 1.8 1.8
868 1.8 1.8 1.8 1.8 0 0 1.8 1.8 1.8 1.8 1.8 1.8 1.8 0
869 0 1.8 0 0 1.8 1.8 1.8 1.8 1.8 1.8 1.8 1.8 1.8 1.8
870 0 0 0 1.8 1.8 1.8 1.8 1.8 1.8 1.8 1.8 1.8 1.8 1.8
871 0 0 0 0 1.8 0 1.8 1.8 1.8 1.8 1.8 1.8 1.8 1.8
872 0 0 0 0 1.8 1.8 1.8 0 1.8 1.8 1.8 1.8 1.8 1.8
873 0 0 0 0 1.8 1.8 1.8 1.8 1.8 0 1.8 1.8 1.8 1.8
874 0 0 0 0 1.8 1.8 1.8 1.8 1.8 1.8 1.8 0 1.8 1.8
875 0 0 0 0 1.8 1.8 1.8 1.8 1.8 1.8 1.8 1.8 1.8 0
876 1.8 0 0 0 1.8 1.8 1.8 1.8 1.8 1.8 1.8 1.8 1.8 1.8
877 1.8 1.8 0 1.8 1.8 1.8 1.8 1.8 1.8 1.8 1.8 1.8 1.8 1.8
878 1.8 1.8 0 0 1.8 0 1.8 1.8 1.8 1.8 1.8 1.8 1.8 1.8
879 1.8 1.8 0 0 1.8 1.8 1.8 0 1.8 1.8 1.8 1.8 1.8 1.8
880 1.8 1.8 0 0 1.8 1.8 1.8 1.8 1.8 0 1.8 1.8 1.8 1.8
881 1.8 1.8 0 0 1.8 1.8 1.8 1.8 1.8 1.8 1.8 0 1.8 1.8
882 1.8 1.8 0 0 1.8 1.8 1.8 1.8 1.8 1.8 1.8 1.8 1.8 0
883 0 1.8 1.8 1.8 1.8 1.8 1.8 1.8 1.8 1.8 1.8 1.8 1.8 1.8
884 0 0 1.8 0 1.8 1.8 1.8 1.8 1.8 1.8 1.8 1.8 1.8 1.8
885 0 0 1.8 1.8 1.8 0 1.8 1.8 1.8 1.8 1.8 1.8 1.8 1.8
886 0 0 1.8 1.8 1.8 1.8 1.8 0 1.8 1.8 1.8 1.8 1.8 1.8
887 0 0 1.8 1.8 1.8 1.8 1.8 1.8 1.8 0 1.8 1.8 1.8 1.8
888 0 0 1.8 1.8 1.8 1.8 1.8 1.8 1.8 1.8 1.8 0 1.8 1.8
889 0 0 1.8 1.8 1.8 1.8 1.8 1.8 1.8 1.8 1.8 1.8 1.8 0
890 1.8 0 1.8 1.8 1.8 1.8 1.8 1.8 1.8 1.8 1.8 1.8 1.8 1.8
891 1.8 1.8 1.8 0 1.8 1.8 1.8 1.8 1.8 1.8 1.8 1.8 1.8 1.8
892 1.8 1.8 1.8 1.8 1.8 0 1.8 1.8 1.8 1.8 1.8 1.8 1.8 1.8
893 1.8 1.8 1.8 1.8 1.8 1.8 1.8 0 1.8 1.8 1.8 1.8 1.8 1.8
894 1.8 1.8 1.8 1.8 1.8 1.8 1.8 1.8 1.8 0 1.8 1.8 1.8 1.8
895 1.8 1.8 1.8 1.8 1.8 1.8 1.8 1.8 1.8 1.8 1.8 0 1.8 1.8
896 1.8 1.8 1.8 1.8 1.8 1.8 1.8 1.8 1.8 1.8 1.8 1.8 1.8 0
.enddata
.tran 2p 3n sweep data=CASES
.meas tran pre_s0 find v(s0) at=0.9n
.meas tran post_s0 find v(s0) at=2.9n
.meas tran d_s0 trig v(ref) val=0.9 rise=1 targ v(s0) val=0.9 cross=last
.meas tran pre_s1 find v(s1) at=0.9n
.meas tran post_s1 find v(s1) at=2.9n
.meas tran d_s1 trig v(ref) val=0.9 rise=1 targ v(s1) val=0.9 cross=last
.meas tran pre_s2 find v(s2) at=0.9n
.meas tran post_s2 find v(s2) at=2.9n
.meas tran d_s2 trig v(ref) val=0.9 rise=1 targ v(s2) val=0.9 cross=last
.meas tran pre_cout find v(cout) at=0.9n
.meas tran post_cout find v(cout) at=2.9n
.meas tran d_cout trig v(ref) val=0.9 rise=1 targ v(cout) val=0.9 cross=last
.end
