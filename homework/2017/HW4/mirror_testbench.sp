* 2017 full-adder verification
.protect
.lib 'D:/cic018.l' tt
.unprotect
vvdd vdd 0 1.8
vvss vss 0 0
.temp 25
.option ingold=2 lis_new=1 numdgt=8 delmax=2p
.include 'mirror_full_adder.sp'
.param WOSS=2.72701u
.param WOSC=2.01793u
va a 0 pwl(
+ 0n 0 4.9n 0 5n 0 9.9n 0 10n 0
+ 14.9n 0 15n 0 19.9n 0 20n 0 24.9n 0
+ 25n 0 29.9n 0 30n 0 34.9n 0 35n 1.8
+ 39.9n 1.8 40n 0 44.9n 0 45n 1.8 49.9n 1.8
+ 50n 0 54.9n 0 55n 1.8 59.9n 1.8 60n 0
+ 64.9n 0 65n 1.8 69.9n 1.8 70n 0 74.9n 0
+ 75n 0 79.9n 0 80n 0 84.9n 0 85n 0
+ 89.9n 0 90n 0 94.9n 0 95n 0 99.9n 0
+ 100n 0 104.9n 0 105n 1.8 109.9n 1.8 110n 0
+ 114.9n 0 115n 1.8 119.9n 1.8 120n 0 124.9n 0
+ 125n 1.8 129.9n 1.8 130n 0 134.9n 0 135n 1.8
+ 139.9n 1.8 140n 0 144.9n 0 145n 0 149.9n 0
+ 150n 0 154.9n 0 155n 0 159.9n 0 160n 0
+ 164.9n 0 165n 0 169.9n 0 170n 0 174.9n 0
+ 175n 1.8 179.9n 1.8 180n 0 184.9n 0 185n 1.8
+ 189.9n 1.8 190n 0 194.9n 0 195n 1.8 199.9n 1.8
+ 200n 0 204.9n 0 205n 1.8 209.9n 1.8 210n 0
+ 214.9n 0 215n 0 219.9n 0 220n 0 224.9n 0
+ 225n 0 229.9n 0 230n 0 234.9n 0 235n 0
+ 239.9n 0 240n 0 244.9n 0 245n 1.8 249.9n 1.8
+ 250n 0 254.9n 0 255n 1.8 259.9n 1.8 260n 0
+ 264.9n 0 265n 1.8 269.9n 1.8 270n 0 274.9n 0
+ 275n 1.8 279.9n 1.8 280n 1.8 284.9n 1.8 285n 0
+ 289.9n 0 290n 1.8 294.9n 1.8 295n 0 299.9n 0
+ 300n 1.8 304.9n 1.8 305n 0 309.9n 0 310n 1.8
+ 314.9n 1.8 315n 0 319.9n 0 320n 1.8 324.9n 1.8
+ 325n 1.8 329.9n 1.8 330n 1.8 334.9n 1.8 335n 1.8
+ 339.9n 1.8 340n 1.8 344.9n 1.8 345n 1.8 349.9n 1.8
+ 350n 1.8 354.9n 1.8 355n 0 359.9n 0 360n 1.8
+ 364.9n 1.8 365n 0 369.9n 0 370n 1.8 374.9n 1.8
+ 375n 0 379.9n 0 380n 1.8 384.9n 1.8 385n 0
+ 389.9n 0 390n 1.8 394.9n 1.8 395n 1.8 399.9n 1.8
+ 400n 1.8 404.9n 1.8 405n 1.8 409.9n 1.8 410n 1.8
+ 414.9n 1.8 415n 1.8 419.9n 1.8 420n 1.8 424.9n 1.8
+ 425n 0 429.9n 0 430n 1.8 434.9n 1.8 435n 0
+ 439.9n 0 440n 1.8 444.9n 1.8 445n 0 449.9n 0
+ 450n 1.8 454.9n 1.8 455n 0 459.9n 0 460n 1.8
+ 464.9n 1.8 465n 1.8 469.9n 1.8 470n 1.8 474.9n 1.8
+ 475n 1.8 479.9n 1.8 480n 1.8 484.9n 1.8 485n 1.8
+ 489.9n 1.8 490n 1.8 494.9n 1.8 495n 0 499.9n 0
+ 500n 1.8 504.9n 1.8 505n 0 509.9n 0 510n 1.8
+ 514.9n 1.8 515n 0 519.9n 0 520n 1.8 524.9n 1.8
+ 525n 0 529.9n 0 530n 1.8 534.9n 1.8 535n 1.8
+ 539.9n 1.8 540n 1.8 544.9n 1.8 545n 1.8 549.9n 1.8
+ 550n 1.8 554.9n 1.8 555n 1.8
+)
vb b 0 pwl(
+ 0n 0 4.9n 0 5n 0 9.9n 0 10n 0
+ 14.9n 0 15n 1.8 19.9n 1.8 20n 0 24.9n 0
+ 25n 1.8 29.9n 1.8 30n 0 34.9n 0 35n 0
+ 39.9n 0 40n 0 44.9n 0 45n 0 49.9n 0
+ 50n 0 54.9n 0 55n 1.8 59.9n 1.8 60n 0
+ 64.9n 0 65n 1.8 69.9n 1.8 70n 0 74.9n 0
+ 75n 0 79.9n 0 80n 0 84.9n 0 85n 1.8
+ 89.9n 1.8 90n 0 94.9n 0 95n 1.8 99.9n 1.8
+ 100n 0 104.9n 0 105n 0 109.9n 0 110n 0
+ 114.9n 0 115n 0 119.9n 0 120n 0 124.9n 0
+ 125n 1.8 129.9n 1.8 130n 0 134.9n 0 135n 1.8
+ 139.9n 1.8 140n 1.8 144.9n 1.8 145n 0 149.9n 0
+ 150n 1.8 154.9n 1.8 155n 0 159.9n 0 160n 1.8
+ 164.9n 1.8 165n 1.8 169.9n 1.8 170n 1.8 174.9n 1.8
+ 175n 0 179.9n 0 180n 1.8 184.9n 1.8 185n 0
+ 189.9n 0 190n 1.8 194.9n 1.8 195n 1.8 199.9n 1.8
+ 200n 1.8 204.9n 1.8 205n 1.8 209.9n 1.8 210n 1.8
+ 214.9n 1.8 215n 0 219.9n 0 220n 1.8 224.9n 1.8
+ 225n 0 229.9n 0 230n 1.8 234.9n 1.8 235n 1.8
+ 239.9n 1.8 240n 1.8 244.9n 1.8 245n 0 249.9n 0
+ 250n 1.8 254.9n 1.8 255n 0 259.9n 0 260n 1.8
+ 264.9n 1.8 265n 1.8 269.9n 1.8 270n 1.8 274.9n 1.8
+ 275n 1.8 279.9n 1.8 280n 0 284.9n 0 285n 0
+ 289.9n 0 290n 0 294.9n 0 295n 0 299.9n 0
+ 300n 0 304.9n 0 305n 1.8 309.9n 1.8 310n 0
+ 314.9n 0 315n 1.8 319.9n 1.8 320n 0 324.9n 0
+ 325n 0 329.9n 0 330n 0 334.9n 0 335n 1.8
+ 339.9n 1.8 340n 0 344.9n 0 345n 1.8 349.9n 1.8
+ 350n 0 354.9n 0 355n 0 359.9n 0 360n 0
+ 364.9n 0 365n 0 369.9n 0 370n 0 374.9n 0
+ 375n 1.8 379.9n 1.8 380n 0 384.9n 0 385n 1.8
+ 389.9n 1.8 390n 0 394.9n 0 395n 0 399.9n 0
+ 400n 0 404.9n 0 405n 1.8 409.9n 1.8 410n 0
+ 414.9n 0 415n 1.8 419.9n 1.8 420n 1.8 424.9n 1.8
+ 425n 0 429.9n 0 430n 1.8 434.9n 1.8 435n 0
+ 439.9n 0 440n 1.8 444.9n 1.8 445n 1.8 449.9n 1.8
+ 450n 1.8 454.9n 1.8 455n 1.8 459.9n 1.8 460n 1.8
+ 464.9n 1.8 465n 0 469.9n 0 470n 1.8 474.9n 1.8
+ 475n 0 479.9n 0 480n 1.8 484.9n 1.8 485n 1.8
+ 489.9n 1.8 490n 1.8 494.9n 1.8 495n 0 499.9n 0
+ 500n 1.8 504.9n 1.8 505n 0 509.9n 0 510n 1.8
+ 514.9n 1.8 515n 1.8 519.9n 1.8 520n 1.8 524.9n 1.8
+ 525n 1.8 529.9n 1.8 530n 1.8 534.9n 1.8 535n 0
+ 539.9n 0 540n 1.8 544.9n 1.8 545n 0 549.9n 0
+ 550n 1.8 554.9n 1.8 555n 1.8
+)
vc c 0 pwl(
+ 0n 0 4.9n 0 5n 1.8 9.9n 1.8 10n 0
+ 14.9n 0 15n 0 19.9n 0 20n 0 24.9n 0
+ 25n 1.8 29.9n 1.8 30n 0 34.9n 0 35n 0
+ 39.9n 0 40n 0 44.9n 0 45n 1.8 49.9n 1.8
+ 50n 0 54.9n 0 55n 0 59.9n 0 60n 0
+ 64.9n 0 65n 1.8 69.9n 1.8 70n 1.8 74.9n 1.8
+ 75n 0 79.9n 0 80n 1.8 84.9n 1.8 85n 0
+ 89.9n 0 90n 1.8 94.9n 1.8 95n 1.8 99.9n 1.8
+ 100n 1.8 104.9n 1.8 105n 0 109.9n 0 110n 1.8
+ 114.9n 1.8 115n 1.8 119.9n 1.8 120n 1.8 124.9n 1.8
+ 125n 0 129.9n 0 130n 1.8 134.9n 1.8 135n 1.8
+ 139.9n 1.8 140n 0 144.9n 0 145n 0 149.9n 0
+ 150n 0 154.9n 0 155n 1.8 159.9n 1.8 160n 0
+ 164.9n 0 165n 1.8 169.9n 1.8 170n 0 174.9n 0
+ 175n 0 179.9n 0 180n 0 184.9n 0 185n 1.8
+ 189.9n 1.8 190n 0 194.9n 0 195n 0 199.9n 0
+ 200n 0 204.9n 0 205n 1.8 209.9n 1.8 210n 1.8
+ 214.9n 1.8 215n 0 219.9n 0 220n 1.8 224.9n 1.8
+ 225n 1.8 229.9n 1.8 230n 1.8 234.9n 1.8 235n 0
+ 239.9n 0 240n 1.8 244.9n 1.8 245n 0 249.9n 0
+ 250n 1.8 254.9n 1.8 255n 1.8 259.9n 1.8 260n 1.8
+ 264.9n 1.8 265n 0 269.9n 0 270n 1.8 274.9n 1.8
+ 275n 1.8 279.9n 1.8 280n 0 284.9n 0 285n 0
+ 289.9n 0 290n 0 294.9n 0 295n 1.8 299.9n 1.8
+ 300n 0 304.9n 0 305n 0 309.9n 0 310n 0
+ 314.9n 0 315n 1.8 319.9n 1.8 320n 0 324.9n 0
+ 325n 1.8 329.9n 1.8 330n 0 334.9n 0 335n 0
+ 339.9n 0 340n 0 344.9n 0 345n 1.8 349.9n 1.8
+ 350n 1.8 354.9n 1.8 355n 0 359.9n 0 360n 1.8
+ 364.9n 1.8 365n 1.8 369.9n 1.8 370n 1.8 374.9n 1.8
+ 375n 0 379.9n 0 380n 1.8 384.9n 1.8 385n 1.8
+ 389.9n 1.8 390n 1.8 394.9n 1.8 395n 0 399.9n 0
+ 400n 1.8 404.9n 1.8 405n 0 409.9n 0 410n 1.8
+ 414.9n 1.8 415n 1.8 419.9n 1.8 420n 0 424.9n 0
+ 425n 0 429.9n 0 430n 0 434.9n 0 435n 1.8
+ 439.9n 1.8 440n 0 444.9n 0 445n 0 449.9n 0
+ 450n 0 454.9n 0 455n 1.8 459.9n 1.8 460n 0
+ 464.9n 0 465n 0 469.9n 0 470n 0 474.9n 0
+ 475n 1.8 479.9n 1.8 480n 0 484.9n 0 485n 1.8
+ 489.9n 1.8 490n 1.8 494.9n 1.8 495n 0 499.9n 0
+ 500n 1.8 504.9n 1.8 505n 1.8 509.9n 1.8 510n 1.8
+ 514.9n 1.8 515n 0 519.9n 0 520n 1.8 524.9n 1.8
+ 525n 1.8 529.9n 1.8 530n 1.8 534.9n 1.8 535n 0
+ 539.9n 0 540n 1.8 544.9n 1.8 545n 1.8 549.9n 1.8
+ 550n 1.8 554.9n 1.8 555n 0
+)
XF a b c s co vdd vss mirror_fa
CLS s 0 1f
CLC co 0 1f
.tran 2p 562n
.print tran v(a) v(b) v(c) v(s) v(co)
.end
