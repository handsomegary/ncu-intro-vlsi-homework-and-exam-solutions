* 2020 HW2 Q2 exhaustive 64 valid one-hot-low cases
.protect
.lib 'D:/cic018.l' TT
.unprotect
.include 'rotator.sp'
.option measform=3 numdgt=10 measdgt=10 delmax=10p ingold=2
.temp 25
VDD vdd 0 1.8
VSS vss 0 0
XROT a0 a1 a2 a3 c0 c1 c2 c3 z0 z1 z2 z3 vdd vss rotator
CL0 z0 0 1f
CL1 z1 0 1f
CL2 z2 0 1f
CL3 z3 0 1f
Va0 a0 vss PWL(
+ 0.000000000000e+00 0.0
+ 2.000000000000e-09 0.0
+ 2.020000000000e-09 1.8
+ 4.000000000000e-09 1.8
+ 4.020000000000e-09 0.0
+ 6.000000000000e-09 0.0
+ 6.020000000000e-09 1.8
+ 8.000000000000e-09 1.8
+ 8.020000000000e-09 0.0
+ 1.000000000000e-08 0.0
+ 1.002000000000e-08 1.8
+ 1.200000000000e-08 1.8
+ 1.202000000000e-08 0.0
+ 1.400000000000e-08 0.0
+ 1.402000000000e-08 1.8
+ 1.600000000000e-08 1.8
+ 1.602000000000e-08 0.0
+ 1.800000000000e-08 0.0
+ 1.802000000000e-08 1.8
+ 2.000000000000e-08 1.8
+ 2.002000000000e-08 0.0
+ 2.200000000000e-08 0.0
+ 2.202000000000e-08 1.8
+ 2.400000000000e-08 1.8
+ 2.402000000000e-08 0.0
+ 2.600000000000e-08 0.0
+ 2.602000000000e-08 1.8
+ 2.800000000000e-08 1.8
+ 2.802000000000e-08 0.0
+ 3.000000000000e-08 0.0
+ 3.002000000000e-08 1.8
+ 3.200000000000e-08 1.8
+ 3.202000000000e-08 0.0
+ 3.400000000000e-08 0.0
+ 3.402000000000e-08 1.8
+ 3.600000000000e-08 1.8
+ 3.602000000000e-08 0.0
+ 3.800000000000e-08 0.0
+ 3.802000000000e-08 1.8
+ 4.000000000000e-08 1.8
+ 4.002000000000e-08 0.0
+ 4.200000000000e-08 0.0
+ 4.202000000000e-08 1.8
+ 4.400000000000e-08 1.8
+ 4.402000000000e-08 0.0
+ 4.600000000000e-08 0.0
+ 4.602000000000e-08 1.8
+ 4.800000000000e-08 1.8
+ 4.802000000000e-08 0.0
+ 5.000000000000e-08 0.0
+ 5.002000000000e-08 1.8
+ 5.200000000000e-08 1.8
+ 5.202000000000e-08 0.0
+ 5.400000000000e-08 0.0
+ 5.402000000000e-08 1.8
+ 5.600000000000e-08 1.8
+ 5.602000000000e-08 0.0
+ 5.800000000000e-08 0.0
+ 5.802000000000e-08 1.8
+ 6.000000000000e-08 1.8
+ 6.002000000000e-08 0.0
+ 6.200000000000e-08 0.0
+ 6.202000000000e-08 1.8
+ 6.400000000000e-08 1.8
+ 6.402000000000e-08 0.0
+ 6.600000000000e-08 0.0
+ 6.602000000000e-08 1.8
+ 6.800000000000e-08 1.8
+ 6.802000000000e-08 0.0
+ 7.000000000000e-08 0.0
+ 7.002000000000e-08 1.8
+ 7.200000000000e-08 1.8
+ 7.202000000000e-08 0.0
+ 7.400000000000e-08 0.0
+ 7.402000000000e-08 1.8
+ 7.600000000000e-08 1.8
+ 7.602000000000e-08 0.0
+ 7.800000000000e-08 0.0
+ 7.802000000000e-08 1.8
+ 8.000000000000e-08 1.8
+ 8.002000000000e-08 0.0
+ 8.200000000000e-08 0.0
+ 8.202000000000e-08 1.8
+ 8.400000000000e-08 1.8
+ 8.402000000000e-08 0.0
+ 8.600000000000e-08 0.0
+ 8.602000000000e-08 1.8
+ 8.800000000000e-08 1.8
+ 8.802000000000e-08 0.0
+ 9.000000000000e-08 0.0
+ 9.002000000000e-08 1.8
+ 9.200000000000e-08 1.8
+ 9.202000000000e-08 0.0
+ 9.400000000000e-08 0.0
+ 9.402000000000e-08 1.8
+ 9.600000000000e-08 1.8
+ 9.602000000000e-08 0.0
+ 9.800000000000e-08 0.0
+ 9.802000000000e-08 1.8
+ 1.000000000000e-07 1.8
+ 1.000200000000e-07 0.0
+ 1.020000000000e-07 0.0
+ 1.020200000000e-07 1.8
+ 1.040000000000e-07 1.8
+ 1.040200000000e-07 0.0
+ 1.060000000000e-07 0.0
+ 1.060200000000e-07 1.8
+ 1.080000000000e-07 1.8
+ 1.080200000000e-07 0.0
+ 1.100000000000e-07 0.0
+ 1.100200000000e-07 1.8
+ 1.120000000000e-07 1.8
+ 1.120200000000e-07 0.0
+ 1.140000000000e-07 0.0
+ 1.140200000000e-07 1.8
+ 1.160000000000e-07 1.8
+ 1.160200000000e-07 0.0
+ 1.180000000000e-07 0.0
+ 1.180200000000e-07 1.8
+ 1.200000000000e-07 1.8
+ 1.200200000000e-07 0.0
+ 1.220000000000e-07 0.0
+ 1.220200000000e-07 1.8
+ 1.240000000000e-07 1.8
+ 1.240200000000e-07 0.0
+ 1.260000000000e-07 0.0
+ 1.260200000000e-07 1.8
+ 1.280000000000e-07 1.8
+)
Va1 a1 vss PWL(
+ 0.000000000000e+00 0.0
+ 2.000000000000e-09 0.0
+ 2.020000000000e-09 0.0
+ 4.000000000000e-09 0.0
+ 4.020000000000e-09 1.8
+ 6.000000000000e-09 1.8
+ 6.020000000000e-09 1.8
+ 8.000000000000e-09 1.8
+ 8.020000000000e-09 0.0
+ 1.000000000000e-08 0.0
+ 1.002000000000e-08 0.0
+ 1.200000000000e-08 0.0
+ 1.202000000000e-08 1.8
+ 1.400000000000e-08 1.8
+ 1.402000000000e-08 1.8
+ 1.600000000000e-08 1.8
+ 1.602000000000e-08 0.0
+ 1.800000000000e-08 0.0
+ 1.802000000000e-08 0.0
+ 2.000000000000e-08 0.0
+ 2.002000000000e-08 1.8
+ 2.200000000000e-08 1.8
+ 2.202000000000e-08 1.8
+ 2.400000000000e-08 1.8
+ 2.402000000000e-08 0.0
+ 2.600000000000e-08 0.0
+ 2.602000000000e-08 0.0
+ 2.800000000000e-08 0.0
+ 2.802000000000e-08 1.8
+ 3.000000000000e-08 1.8
+ 3.002000000000e-08 1.8
+ 3.200000000000e-08 1.8
+ 3.202000000000e-08 0.0
+ 3.400000000000e-08 0.0
+ 3.402000000000e-08 0.0
+ 3.600000000000e-08 0.0
+ 3.602000000000e-08 1.8
+ 3.800000000000e-08 1.8
+ 3.802000000000e-08 1.8
+ 4.000000000000e-08 1.8
+ 4.002000000000e-08 0.0
+ 4.200000000000e-08 0.0
+ 4.202000000000e-08 0.0
+ 4.400000000000e-08 0.0
+ 4.402000000000e-08 1.8
+ 4.600000000000e-08 1.8
+ 4.602000000000e-08 1.8
+ 4.800000000000e-08 1.8
+ 4.802000000000e-08 0.0
+ 5.000000000000e-08 0.0
+ 5.002000000000e-08 0.0
+ 5.200000000000e-08 0.0
+ 5.202000000000e-08 1.8
+ 5.400000000000e-08 1.8
+ 5.402000000000e-08 1.8
+ 5.600000000000e-08 1.8
+ 5.602000000000e-08 0.0
+ 5.800000000000e-08 0.0
+ 5.802000000000e-08 0.0
+ 6.000000000000e-08 0.0
+ 6.002000000000e-08 1.8
+ 6.200000000000e-08 1.8
+ 6.202000000000e-08 1.8
+ 6.400000000000e-08 1.8
+ 6.402000000000e-08 0.0
+ 6.600000000000e-08 0.0
+ 6.602000000000e-08 0.0
+ 6.800000000000e-08 0.0
+ 6.802000000000e-08 1.8
+ 7.000000000000e-08 1.8
+ 7.002000000000e-08 1.8
+ 7.200000000000e-08 1.8
+ 7.202000000000e-08 0.0
+ 7.400000000000e-08 0.0
+ 7.402000000000e-08 0.0
+ 7.600000000000e-08 0.0
+ 7.602000000000e-08 1.8
+ 7.800000000000e-08 1.8
+ 7.802000000000e-08 1.8
+ 8.000000000000e-08 1.8
+ 8.002000000000e-08 0.0
+ 8.200000000000e-08 0.0
+ 8.202000000000e-08 0.0
+ 8.400000000000e-08 0.0
+ 8.402000000000e-08 1.8
+ 8.600000000000e-08 1.8
+ 8.602000000000e-08 1.8
+ 8.800000000000e-08 1.8
+ 8.802000000000e-08 0.0
+ 9.000000000000e-08 0.0
+ 9.002000000000e-08 0.0
+ 9.200000000000e-08 0.0
+ 9.202000000000e-08 1.8
+ 9.400000000000e-08 1.8
+ 9.402000000000e-08 1.8
+ 9.600000000000e-08 1.8
+ 9.602000000000e-08 0.0
+ 9.800000000000e-08 0.0
+ 9.802000000000e-08 0.0
+ 1.000000000000e-07 0.0
+ 1.000200000000e-07 1.8
+ 1.020000000000e-07 1.8
+ 1.020200000000e-07 1.8
+ 1.040000000000e-07 1.8
+ 1.040200000000e-07 0.0
+ 1.060000000000e-07 0.0
+ 1.060200000000e-07 0.0
+ 1.080000000000e-07 0.0
+ 1.080200000000e-07 1.8
+ 1.100000000000e-07 1.8
+ 1.100200000000e-07 1.8
+ 1.120000000000e-07 1.8
+ 1.120200000000e-07 0.0
+ 1.140000000000e-07 0.0
+ 1.140200000000e-07 0.0
+ 1.160000000000e-07 0.0
+ 1.160200000000e-07 1.8
+ 1.180000000000e-07 1.8
+ 1.180200000000e-07 1.8
+ 1.200000000000e-07 1.8
+ 1.200200000000e-07 0.0
+ 1.220000000000e-07 0.0
+ 1.220200000000e-07 0.0
+ 1.240000000000e-07 0.0
+ 1.240200000000e-07 1.8
+ 1.260000000000e-07 1.8
+ 1.260200000000e-07 1.8
+ 1.280000000000e-07 1.8
+)
Va2 a2 vss PWL(
+ 0.000000000000e+00 0.0
+ 2.000000000000e-09 0.0
+ 2.020000000000e-09 0.0
+ 4.000000000000e-09 0.0
+ 4.020000000000e-09 0.0
+ 6.000000000000e-09 0.0
+ 6.020000000000e-09 0.0
+ 8.000000000000e-09 0.0
+ 8.020000000000e-09 1.8
+ 1.000000000000e-08 1.8
+ 1.002000000000e-08 1.8
+ 1.200000000000e-08 1.8
+ 1.202000000000e-08 1.8
+ 1.400000000000e-08 1.8
+ 1.402000000000e-08 1.8
+ 1.600000000000e-08 1.8
+ 1.602000000000e-08 0.0
+ 1.800000000000e-08 0.0
+ 1.802000000000e-08 0.0
+ 2.000000000000e-08 0.0
+ 2.002000000000e-08 0.0
+ 2.200000000000e-08 0.0
+ 2.202000000000e-08 0.0
+ 2.400000000000e-08 0.0
+ 2.402000000000e-08 1.8
+ 2.600000000000e-08 1.8
+ 2.602000000000e-08 1.8
+ 2.800000000000e-08 1.8
+ 2.802000000000e-08 1.8
+ 3.000000000000e-08 1.8
+ 3.002000000000e-08 1.8
+ 3.200000000000e-08 1.8
+ 3.202000000000e-08 0.0
+ 3.400000000000e-08 0.0
+ 3.402000000000e-08 0.0
+ 3.600000000000e-08 0.0
+ 3.602000000000e-08 0.0
+ 3.800000000000e-08 0.0
+ 3.802000000000e-08 0.0
+ 4.000000000000e-08 0.0
+ 4.002000000000e-08 1.8
+ 4.200000000000e-08 1.8
+ 4.202000000000e-08 1.8
+ 4.400000000000e-08 1.8
+ 4.402000000000e-08 1.8
+ 4.600000000000e-08 1.8
+ 4.602000000000e-08 1.8
+ 4.800000000000e-08 1.8
+ 4.802000000000e-08 0.0
+ 5.000000000000e-08 0.0
+ 5.002000000000e-08 0.0
+ 5.200000000000e-08 0.0
+ 5.202000000000e-08 0.0
+ 5.400000000000e-08 0.0
+ 5.402000000000e-08 0.0
+ 5.600000000000e-08 0.0
+ 5.602000000000e-08 1.8
+ 5.800000000000e-08 1.8
+ 5.802000000000e-08 1.8
+ 6.000000000000e-08 1.8
+ 6.002000000000e-08 1.8
+ 6.200000000000e-08 1.8
+ 6.202000000000e-08 1.8
+ 6.400000000000e-08 1.8
+ 6.402000000000e-08 0.0
+ 6.600000000000e-08 0.0
+ 6.602000000000e-08 0.0
+ 6.800000000000e-08 0.0
+ 6.802000000000e-08 0.0
+ 7.000000000000e-08 0.0
+ 7.002000000000e-08 0.0
+ 7.200000000000e-08 0.0
+ 7.202000000000e-08 1.8
+ 7.400000000000e-08 1.8
+ 7.402000000000e-08 1.8
+ 7.600000000000e-08 1.8
+ 7.602000000000e-08 1.8
+ 7.800000000000e-08 1.8
+ 7.802000000000e-08 1.8
+ 8.000000000000e-08 1.8
+ 8.002000000000e-08 0.0
+ 8.200000000000e-08 0.0
+ 8.202000000000e-08 0.0
+ 8.400000000000e-08 0.0
+ 8.402000000000e-08 0.0
+ 8.600000000000e-08 0.0
+ 8.602000000000e-08 0.0
+ 8.800000000000e-08 0.0
+ 8.802000000000e-08 1.8
+ 9.000000000000e-08 1.8
+ 9.002000000000e-08 1.8
+ 9.200000000000e-08 1.8
+ 9.202000000000e-08 1.8
+ 9.400000000000e-08 1.8
+ 9.402000000000e-08 1.8
+ 9.600000000000e-08 1.8
+ 9.602000000000e-08 0.0
+ 9.800000000000e-08 0.0
+ 9.802000000000e-08 0.0
+ 1.000000000000e-07 0.0
+ 1.000200000000e-07 0.0
+ 1.020000000000e-07 0.0
+ 1.020200000000e-07 0.0
+ 1.040000000000e-07 0.0
+ 1.040200000000e-07 1.8
+ 1.060000000000e-07 1.8
+ 1.060200000000e-07 1.8
+ 1.080000000000e-07 1.8
+ 1.080200000000e-07 1.8
+ 1.100000000000e-07 1.8
+ 1.100200000000e-07 1.8
+ 1.120000000000e-07 1.8
+ 1.120200000000e-07 0.0
+ 1.140000000000e-07 0.0
+ 1.140200000000e-07 0.0
+ 1.160000000000e-07 0.0
+ 1.160200000000e-07 0.0
+ 1.180000000000e-07 0.0
+ 1.180200000000e-07 0.0
+ 1.200000000000e-07 0.0
+ 1.200200000000e-07 1.8
+ 1.220000000000e-07 1.8
+ 1.220200000000e-07 1.8
+ 1.240000000000e-07 1.8
+ 1.240200000000e-07 1.8
+ 1.260000000000e-07 1.8
+ 1.260200000000e-07 1.8
+ 1.280000000000e-07 1.8
+)
Va3 a3 vss PWL(
+ 0.000000000000e+00 0.0
+ 2.000000000000e-09 0.0
+ 2.020000000000e-09 0.0
+ 4.000000000000e-09 0.0
+ 4.020000000000e-09 0.0
+ 6.000000000000e-09 0.0
+ 6.020000000000e-09 0.0
+ 8.000000000000e-09 0.0
+ 8.020000000000e-09 0.0
+ 1.000000000000e-08 0.0
+ 1.002000000000e-08 0.0
+ 1.200000000000e-08 0.0
+ 1.202000000000e-08 0.0
+ 1.400000000000e-08 0.0
+ 1.402000000000e-08 0.0
+ 1.600000000000e-08 0.0
+ 1.602000000000e-08 1.8
+ 1.800000000000e-08 1.8
+ 1.802000000000e-08 1.8
+ 2.000000000000e-08 1.8
+ 2.002000000000e-08 1.8
+ 2.200000000000e-08 1.8
+ 2.202000000000e-08 1.8
+ 2.400000000000e-08 1.8
+ 2.402000000000e-08 1.8
+ 2.600000000000e-08 1.8
+ 2.602000000000e-08 1.8
+ 2.800000000000e-08 1.8
+ 2.802000000000e-08 1.8
+ 3.000000000000e-08 1.8
+ 3.002000000000e-08 1.8
+ 3.200000000000e-08 1.8
+ 3.202000000000e-08 0.0
+ 3.400000000000e-08 0.0
+ 3.402000000000e-08 0.0
+ 3.600000000000e-08 0.0
+ 3.602000000000e-08 0.0
+ 3.800000000000e-08 0.0
+ 3.802000000000e-08 0.0
+ 4.000000000000e-08 0.0
+ 4.002000000000e-08 0.0
+ 4.200000000000e-08 0.0
+ 4.202000000000e-08 0.0
+ 4.400000000000e-08 0.0
+ 4.402000000000e-08 0.0
+ 4.600000000000e-08 0.0
+ 4.602000000000e-08 0.0
+ 4.800000000000e-08 0.0
+ 4.802000000000e-08 1.8
+ 5.000000000000e-08 1.8
+ 5.002000000000e-08 1.8
+ 5.200000000000e-08 1.8
+ 5.202000000000e-08 1.8
+ 5.400000000000e-08 1.8
+ 5.402000000000e-08 1.8
+ 5.600000000000e-08 1.8
+ 5.602000000000e-08 1.8
+ 5.800000000000e-08 1.8
+ 5.802000000000e-08 1.8
+ 6.000000000000e-08 1.8
+ 6.002000000000e-08 1.8
+ 6.200000000000e-08 1.8
+ 6.202000000000e-08 1.8
+ 6.400000000000e-08 1.8
+ 6.402000000000e-08 0.0
+ 6.600000000000e-08 0.0
+ 6.602000000000e-08 0.0
+ 6.800000000000e-08 0.0
+ 6.802000000000e-08 0.0
+ 7.000000000000e-08 0.0
+ 7.002000000000e-08 0.0
+ 7.200000000000e-08 0.0
+ 7.202000000000e-08 0.0
+ 7.400000000000e-08 0.0
+ 7.402000000000e-08 0.0
+ 7.600000000000e-08 0.0
+ 7.602000000000e-08 0.0
+ 7.800000000000e-08 0.0
+ 7.802000000000e-08 0.0
+ 8.000000000000e-08 0.0
+ 8.002000000000e-08 1.8
+ 8.200000000000e-08 1.8
+ 8.202000000000e-08 1.8
+ 8.400000000000e-08 1.8
+ 8.402000000000e-08 1.8
+ 8.600000000000e-08 1.8
+ 8.602000000000e-08 1.8
+ 8.800000000000e-08 1.8
+ 8.802000000000e-08 1.8
+ 9.000000000000e-08 1.8
+ 9.002000000000e-08 1.8
+ 9.200000000000e-08 1.8
+ 9.202000000000e-08 1.8
+ 9.400000000000e-08 1.8
+ 9.402000000000e-08 1.8
+ 9.600000000000e-08 1.8
+ 9.602000000000e-08 0.0
+ 9.800000000000e-08 0.0
+ 9.802000000000e-08 0.0
+ 1.000000000000e-07 0.0
+ 1.000200000000e-07 0.0
+ 1.020000000000e-07 0.0
+ 1.020200000000e-07 0.0
+ 1.040000000000e-07 0.0
+ 1.040200000000e-07 0.0
+ 1.060000000000e-07 0.0
+ 1.060200000000e-07 0.0
+ 1.080000000000e-07 0.0
+ 1.080200000000e-07 0.0
+ 1.100000000000e-07 0.0
+ 1.100200000000e-07 0.0
+ 1.120000000000e-07 0.0
+ 1.120200000000e-07 1.8
+ 1.140000000000e-07 1.8
+ 1.140200000000e-07 1.8
+ 1.160000000000e-07 1.8
+ 1.160200000000e-07 1.8
+ 1.180000000000e-07 1.8
+ 1.180200000000e-07 1.8
+ 1.200000000000e-07 1.8
+ 1.200200000000e-07 1.8
+ 1.220000000000e-07 1.8
+ 1.220200000000e-07 1.8
+ 1.240000000000e-07 1.8
+ 1.240200000000e-07 1.8
+ 1.260000000000e-07 1.8
+ 1.260200000000e-07 1.8
+ 1.280000000000e-07 1.8
+)
Vc0 c0 vss PWL(
+ 0.000000000000e+00 0.0
+ 2.000000000000e-09 0.0
+ 2.020000000000e-09 0.0
+ 4.000000000000e-09 0.0
+ 4.020000000000e-09 0.0
+ 6.000000000000e-09 0.0
+ 6.020000000000e-09 0.0
+ 8.000000000000e-09 0.0
+ 8.020000000000e-09 0.0
+ 1.000000000000e-08 0.0
+ 1.002000000000e-08 0.0
+ 1.200000000000e-08 0.0
+ 1.202000000000e-08 0.0
+ 1.400000000000e-08 0.0
+ 1.402000000000e-08 0.0
+ 1.600000000000e-08 0.0
+ 1.602000000000e-08 0.0
+ 1.800000000000e-08 0.0
+ 1.802000000000e-08 0.0
+ 2.000000000000e-08 0.0
+ 2.002000000000e-08 0.0
+ 2.200000000000e-08 0.0
+ 2.202000000000e-08 0.0
+ 2.400000000000e-08 0.0
+ 2.402000000000e-08 0.0
+ 2.600000000000e-08 0.0
+ 2.602000000000e-08 0.0
+ 2.800000000000e-08 0.0
+ 2.802000000000e-08 0.0
+ 3.000000000000e-08 0.0
+ 3.002000000000e-08 0.0
+ 3.200000000000e-08 0.0
+ 3.202000000000e-08 1.8
+ 3.400000000000e-08 1.8
+ 3.402000000000e-08 1.8
+ 3.600000000000e-08 1.8
+ 3.602000000000e-08 1.8
+ 3.800000000000e-08 1.8
+ 3.802000000000e-08 1.8
+ 4.000000000000e-08 1.8
+ 4.002000000000e-08 1.8
+ 4.200000000000e-08 1.8
+ 4.202000000000e-08 1.8
+ 4.400000000000e-08 1.8
+ 4.402000000000e-08 1.8
+ 4.600000000000e-08 1.8
+ 4.602000000000e-08 1.8
+ 4.800000000000e-08 1.8
+ 4.802000000000e-08 1.8
+ 5.000000000000e-08 1.8
+ 5.002000000000e-08 1.8
+ 5.200000000000e-08 1.8
+ 5.202000000000e-08 1.8
+ 5.400000000000e-08 1.8
+ 5.402000000000e-08 1.8
+ 5.600000000000e-08 1.8
+ 5.602000000000e-08 1.8
+ 5.800000000000e-08 1.8
+ 5.802000000000e-08 1.8
+ 6.000000000000e-08 1.8
+ 6.002000000000e-08 1.8
+ 6.200000000000e-08 1.8
+ 6.202000000000e-08 1.8
+ 6.400000000000e-08 1.8
+ 6.402000000000e-08 1.8
+ 6.600000000000e-08 1.8
+ 6.602000000000e-08 1.8
+ 6.800000000000e-08 1.8
+ 6.802000000000e-08 1.8
+ 7.000000000000e-08 1.8
+ 7.002000000000e-08 1.8
+ 7.200000000000e-08 1.8
+ 7.202000000000e-08 1.8
+ 7.400000000000e-08 1.8
+ 7.402000000000e-08 1.8
+ 7.600000000000e-08 1.8
+ 7.602000000000e-08 1.8
+ 7.800000000000e-08 1.8
+ 7.802000000000e-08 1.8
+ 8.000000000000e-08 1.8
+ 8.002000000000e-08 1.8
+ 8.200000000000e-08 1.8
+ 8.202000000000e-08 1.8
+ 8.400000000000e-08 1.8
+ 8.402000000000e-08 1.8
+ 8.600000000000e-08 1.8
+ 8.602000000000e-08 1.8
+ 8.800000000000e-08 1.8
+ 8.802000000000e-08 1.8
+ 9.000000000000e-08 1.8
+ 9.002000000000e-08 1.8
+ 9.200000000000e-08 1.8
+ 9.202000000000e-08 1.8
+ 9.400000000000e-08 1.8
+ 9.402000000000e-08 1.8
+ 9.600000000000e-08 1.8
+ 9.602000000000e-08 1.8
+ 9.800000000000e-08 1.8
+ 9.802000000000e-08 1.8
+ 1.000000000000e-07 1.8
+ 1.000200000000e-07 1.8
+ 1.020000000000e-07 1.8
+ 1.020200000000e-07 1.8
+ 1.040000000000e-07 1.8
+ 1.040200000000e-07 1.8
+ 1.060000000000e-07 1.8
+ 1.060200000000e-07 1.8
+ 1.080000000000e-07 1.8
+ 1.080200000000e-07 1.8
+ 1.100000000000e-07 1.8
+ 1.100200000000e-07 1.8
+ 1.120000000000e-07 1.8
+ 1.120200000000e-07 1.8
+ 1.140000000000e-07 1.8
+ 1.140200000000e-07 1.8
+ 1.160000000000e-07 1.8
+ 1.160200000000e-07 1.8
+ 1.180000000000e-07 1.8
+ 1.180200000000e-07 1.8
+ 1.200000000000e-07 1.8
+ 1.200200000000e-07 1.8
+ 1.220000000000e-07 1.8
+ 1.220200000000e-07 1.8
+ 1.240000000000e-07 1.8
+ 1.240200000000e-07 1.8
+ 1.260000000000e-07 1.8
+ 1.260200000000e-07 1.8
+ 1.280000000000e-07 1.8
+)
Vc1 c1 vss PWL(
+ 0.000000000000e+00 1.8
+ 2.000000000000e-09 1.8
+ 2.020000000000e-09 1.8
+ 4.000000000000e-09 1.8
+ 4.020000000000e-09 1.8
+ 6.000000000000e-09 1.8
+ 6.020000000000e-09 1.8
+ 8.000000000000e-09 1.8
+ 8.020000000000e-09 1.8
+ 1.000000000000e-08 1.8
+ 1.002000000000e-08 1.8
+ 1.200000000000e-08 1.8
+ 1.202000000000e-08 1.8
+ 1.400000000000e-08 1.8
+ 1.402000000000e-08 1.8
+ 1.600000000000e-08 1.8
+ 1.602000000000e-08 1.8
+ 1.800000000000e-08 1.8
+ 1.802000000000e-08 1.8
+ 2.000000000000e-08 1.8
+ 2.002000000000e-08 1.8
+ 2.200000000000e-08 1.8
+ 2.202000000000e-08 1.8
+ 2.400000000000e-08 1.8
+ 2.402000000000e-08 1.8
+ 2.600000000000e-08 1.8
+ 2.602000000000e-08 1.8
+ 2.800000000000e-08 1.8
+ 2.802000000000e-08 1.8
+ 3.000000000000e-08 1.8
+ 3.002000000000e-08 1.8
+ 3.200000000000e-08 1.8
+ 3.202000000000e-08 0.0
+ 3.400000000000e-08 0.0
+ 3.402000000000e-08 0.0
+ 3.600000000000e-08 0.0
+ 3.602000000000e-08 0.0
+ 3.800000000000e-08 0.0
+ 3.802000000000e-08 0.0
+ 4.000000000000e-08 0.0
+ 4.002000000000e-08 0.0
+ 4.200000000000e-08 0.0
+ 4.202000000000e-08 0.0
+ 4.400000000000e-08 0.0
+ 4.402000000000e-08 0.0
+ 4.600000000000e-08 0.0
+ 4.602000000000e-08 0.0
+ 4.800000000000e-08 0.0
+ 4.802000000000e-08 0.0
+ 5.000000000000e-08 0.0
+ 5.002000000000e-08 0.0
+ 5.200000000000e-08 0.0
+ 5.202000000000e-08 0.0
+ 5.400000000000e-08 0.0
+ 5.402000000000e-08 0.0
+ 5.600000000000e-08 0.0
+ 5.602000000000e-08 0.0
+ 5.800000000000e-08 0.0
+ 5.802000000000e-08 0.0
+ 6.000000000000e-08 0.0
+ 6.002000000000e-08 0.0
+ 6.200000000000e-08 0.0
+ 6.202000000000e-08 0.0
+ 6.400000000000e-08 0.0
+ 6.402000000000e-08 1.8
+ 6.600000000000e-08 1.8
+ 6.602000000000e-08 1.8
+ 6.800000000000e-08 1.8
+ 6.802000000000e-08 1.8
+ 7.000000000000e-08 1.8
+ 7.002000000000e-08 1.8
+ 7.200000000000e-08 1.8
+ 7.202000000000e-08 1.8
+ 7.400000000000e-08 1.8
+ 7.402000000000e-08 1.8
+ 7.600000000000e-08 1.8
+ 7.602000000000e-08 1.8
+ 7.800000000000e-08 1.8
+ 7.802000000000e-08 1.8
+ 8.000000000000e-08 1.8
+ 8.002000000000e-08 1.8
+ 8.200000000000e-08 1.8
+ 8.202000000000e-08 1.8
+ 8.400000000000e-08 1.8
+ 8.402000000000e-08 1.8
+ 8.600000000000e-08 1.8
+ 8.602000000000e-08 1.8
+ 8.800000000000e-08 1.8
+ 8.802000000000e-08 1.8
+ 9.000000000000e-08 1.8
+ 9.002000000000e-08 1.8
+ 9.200000000000e-08 1.8
+ 9.202000000000e-08 1.8
+ 9.400000000000e-08 1.8
+ 9.402000000000e-08 1.8
+ 9.600000000000e-08 1.8
+ 9.602000000000e-08 1.8
+ 9.800000000000e-08 1.8
+ 9.802000000000e-08 1.8
+ 1.000000000000e-07 1.8
+ 1.000200000000e-07 1.8
+ 1.020000000000e-07 1.8
+ 1.020200000000e-07 1.8
+ 1.040000000000e-07 1.8
+ 1.040200000000e-07 1.8
+ 1.060000000000e-07 1.8
+ 1.060200000000e-07 1.8
+ 1.080000000000e-07 1.8
+ 1.080200000000e-07 1.8
+ 1.100000000000e-07 1.8
+ 1.100200000000e-07 1.8
+ 1.120000000000e-07 1.8
+ 1.120200000000e-07 1.8
+ 1.140000000000e-07 1.8
+ 1.140200000000e-07 1.8
+ 1.160000000000e-07 1.8
+ 1.160200000000e-07 1.8
+ 1.180000000000e-07 1.8
+ 1.180200000000e-07 1.8
+ 1.200000000000e-07 1.8
+ 1.200200000000e-07 1.8
+ 1.220000000000e-07 1.8
+ 1.220200000000e-07 1.8
+ 1.240000000000e-07 1.8
+ 1.240200000000e-07 1.8
+ 1.260000000000e-07 1.8
+ 1.260200000000e-07 1.8
+ 1.280000000000e-07 1.8
+)
Vc2 c2 vss PWL(
+ 0.000000000000e+00 1.8
+ 2.000000000000e-09 1.8
+ 2.020000000000e-09 1.8
+ 4.000000000000e-09 1.8
+ 4.020000000000e-09 1.8
+ 6.000000000000e-09 1.8
+ 6.020000000000e-09 1.8
+ 8.000000000000e-09 1.8
+ 8.020000000000e-09 1.8
+ 1.000000000000e-08 1.8
+ 1.002000000000e-08 1.8
+ 1.200000000000e-08 1.8
+ 1.202000000000e-08 1.8
+ 1.400000000000e-08 1.8
+ 1.402000000000e-08 1.8
+ 1.600000000000e-08 1.8
+ 1.602000000000e-08 1.8
+ 1.800000000000e-08 1.8
+ 1.802000000000e-08 1.8
+ 2.000000000000e-08 1.8
+ 2.002000000000e-08 1.8
+ 2.200000000000e-08 1.8
+ 2.202000000000e-08 1.8
+ 2.400000000000e-08 1.8
+ 2.402000000000e-08 1.8
+ 2.600000000000e-08 1.8
+ 2.602000000000e-08 1.8
+ 2.800000000000e-08 1.8
+ 2.802000000000e-08 1.8
+ 3.000000000000e-08 1.8
+ 3.002000000000e-08 1.8
+ 3.200000000000e-08 1.8
+ 3.202000000000e-08 1.8
+ 3.400000000000e-08 1.8
+ 3.402000000000e-08 1.8
+ 3.600000000000e-08 1.8
+ 3.602000000000e-08 1.8
+ 3.800000000000e-08 1.8
+ 3.802000000000e-08 1.8
+ 4.000000000000e-08 1.8
+ 4.002000000000e-08 1.8
+ 4.200000000000e-08 1.8
+ 4.202000000000e-08 1.8
+ 4.400000000000e-08 1.8
+ 4.402000000000e-08 1.8
+ 4.600000000000e-08 1.8
+ 4.602000000000e-08 1.8
+ 4.800000000000e-08 1.8
+ 4.802000000000e-08 1.8
+ 5.000000000000e-08 1.8
+ 5.002000000000e-08 1.8
+ 5.200000000000e-08 1.8
+ 5.202000000000e-08 1.8
+ 5.400000000000e-08 1.8
+ 5.402000000000e-08 1.8
+ 5.600000000000e-08 1.8
+ 5.602000000000e-08 1.8
+ 5.800000000000e-08 1.8
+ 5.802000000000e-08 1.8
+ 6.000000000000e-08 1.8
+ 6.002000000000e-08 1.8
+ 6.200000000000e-08 1.8
+ 6.202000000000e-08 1.8
+ 6.400000000000e-08 1.8
+ 6.402000000000e-08 0.0
+ 6.600000000000e-08 0.0
+ 6.602000000000e-08 0.0
+ 6.800000000000e-08 0.0
+ 6.802000000000e-08 0.0
+ 7.000000000000e-08 0.0
+ 7.002000000000e-08 0.0
+ 7.200000000000e-08 0.0
+ 7.202000000000e-08 0.0
+ 7.400000000000e-08 0.0
+ 7.402000000000e-08 0.0
+ 7.600000000000e-08 0.0
+ 7.602000000000e-08 0.0
+ 7.800000000000e-08 0.0
+ 7.802000000000e-08 0.0
+ 8.000000000000e-08 0.0
+ 8.002000000000e-08 0.0
+ 8.200000000000e-08 0.0
+ 8.202000000000e-08 0.0
+ 8.400000000000e-08 0.0
+ 8.402000000000e-08 0.0
+ 8.600000000000e-08 0.0
+ 8.602000000000e-08 0.0
+ 8.800000000000e-08 0.0
+ 8.802000000000e-08 0.0
+ 9.000000000000e-08 0.0
+ 9.002000000000e-08 0.0
+ 9.200000000000e-08 0.0
+ 9.202000000000e-08 0.0
+ 9.400000000000e-08 0.0
+ 9.402000000000e-08 0.0
+ 9.600000000000e-08 0.0
+ 9.602000000000e-08 1.8
+ 9.800000000000e-08 1.8
+ 9.802000000000e-08 1.8
+ 1.000000000000e-07 1.8
+ 1.000200000000e-07 1.8
+ 1.020000000000e-07 1.8
+ 1.020200000000e-07 1.8
+ 1.040000000000e-07 1.8
+ 1.040200000000e-07 1.8
+ 1.060000000000e-07 1.8
+ 1.060200000000e-07 1.8
+ 1.080000000000e-07 1.8
+ 1.080200000000e-07 1.8
+ 1.100000000000e-07 1.8
+ 1.100200000000e-07 1.8
+ 1.120000000000e-07 1.8
+ 1.120200000000e-07 1.8
+ 1.140000000000e-07 1.8
+ 1.140200000000e-07 1.8
+ 1.160000000000e-07 1.8
+ 1.160200000000e-07 1.8
+ 1.180000000000e-07 1.8
+ 1.180200000000e-07 1.8
+ 1.200000000000e-07 1.8
+ 1.200200000000e-07 1.8
+ 1.220000000000e-07 1.8
+ 1.220200000000e-07 1.8
+ 1.240000000000e-07 1.8
+ 1.240200000000e-07 1.8
+ 1.260000000000e-07 1.8
+ 1.260200000000e-07 1.8
+ 1.280000000000e-07 1.8
+)
Vc3 c3 vss PWL(
+ 0.000000000000e+00 1.8
+ 2.000000000000e-09 1.8
+ 2.020000000000e-09 1.8
+ 4.000000000000e-09 1.8
+ 4.020000000000e-09 1.8
+ 6.000000000000e-09 1.8
+ 6.020000000000e-09 1.8
+ 8.000000000000e-09 1.8
+ 8.020000000000e-09 1.8
+ 1.000000000000e-08 1.8
+ 1.002000000000e-08 1.8
+ 1.200000000000e-08 1.8
+ 1.202000000000e-08 1.8
+ 1.400000000000e-08 1.8
+ 1.402000000000e-08 1.8
+ 1.600000000000e-08 1.8
+ 1.602000000000e-08 1.8
+ 1.800000000000e-08 1.8
+ 1.802000000000e-08 1.8
+ 2.000000000000e-08 1.8
+ 2.002000000000e-08 1.8
+ 2.200000000000e-08 1.8
+ 2.202000000000e-08 1.8
+ 2.400000000000e-08 1.8
+ 2.402000000000e-08 1.8
+ 2.600000000000e-08 1.8
+ 2.602000000000e-08 1.8
+ 2.800000000000e-08 1.8
+ 2.802000000000e-08 1.8
+ 3.000000000000e-08 1.8
+ 3.002000000000e-08 1.8
+ 3.200000000000e-08 1.8
+ 3.202000000000e-08 1.8
+ 3.400000000000e-08 1.8
+ 3.402000000000e-08 1.8
+ 3.600000000000e-08 1.8
+ 3.602000000000e-08 1.8
+ 3.800000000000e-08 1.8
+ 3.802000000000e-08 1.8
+ 4.000000000000e-08 1.8
+ 4.002000000000e-08 1.8
+ 4.200000000000e-08 1.8
+ 4.202000000000e-08 1.8
+ 4.400000000000e-08 1.8
+ 4.402000000000e-08 1.8
+ 4.600000000000e-08 1.8
+ 4.602000000000e-08 1.8
+ 4.800000000000e-08 1.8
+ 4.802000000000e-08 1.8
+ 5.000000000000e-08 1.8
+ 5.002000000000e-08 1.8
+ 5.200000000000e-08 1.8
+ 5.202000000000e-08 1.8
+ 5.400000000000e-08 1.8
+ 5.402000000000e-08 1.8
+ 5.600000000000e-08 1.8
+ 5.602000000000e-08 1.8
+ 5.800000000000e-08 1.8
+ 5.802000000000e-08 1.8
+ 6.000000000000e-08 1.8
+ 6.002000000000e-08 1.8
+ 6.200000000000e-08 1.8
+ 6.202000000000e-08 1.8
+ 6.400000000000e-08 1.8
+ 6.402000000000e-08 1.8
+ 6.600000000000e-08 1.8
+ 6.602000000000e-08 1.8
+ 6.800000000000e-08 1.8
+ 6.802000000000e-08 1.8
+ 7.000000000000e-08 1.8
+ 7.002000000000e-08 1.8
+ 7.200000000000e-08 1.8
+ 7.202000000000e-08 1.8
+ 7.400000000000e-08 1.8
+ 7.402000000000e-08 1.8
+ 7.600000000000e-08 1.8
+ 7.602000000000e-08 1.8
+ 7.800000000000e-08 1.8
+ 7.802000000000e-08 1.8
+ 8.000000000000e-08 1.8
+ 8.002000000000e-08 1.8
+ 8.200000000000e-08 1.8
+ 8.202000000000e-08 1.8
+ 8.400000000000e-08 1.8
+ 8.402000000000e-08 1.8
+ 8.600000000000e-08 1.8
+ 8.602000000000e-08 1.8
+ 8.800000000000e-08 1.8
+ 8.802000000000e-08 1.8
+ 9.000000000000e-08 1.8
+ 9.002000000000e-08 1.8
+ 9.200000000000e-08 1.8
+ 9.202000000000e-08 1.8
+ 9.400000000000e-08 1.8
+ 9.402000000000e-08 1.8
+ 9.600000000000e-08 1.8
+ 9.602000000000e-08 0.0
+ 9.800000000000e-08 0.0
+ 9.802000000000e-08 0.0
+ 1.000000000000e-07 0.0
+ 1.000200000000e-07 0.0
+ 1.020000000000e-07 0.0
+ 1.020200000000e-07 0.0
+ 1.040000000000e-07 0.0
+ 1.040200000000e-07 0.0
+ 1.060000000000e-07 0.0
+ 1.060200000000e-07 0.0
+ 1.080000000000e-07 0.0
+ 1.080200000000e-07 0.0
+ 1.100000000000e-07 0.0
+ 1.100200000000e-07 0.0
+ 1.120000000000e-07 0.0
+ 1.120200000000e-07 0.0
+ 1.140000000000e-07 0.0
+ 1.140200000000e-07 0.0
+ 1.160000000000e-07 0.0
+ 1.160200000000e-07 0.0
+ 1.180000000000e-07 0.0
+ 1.180200000000e-07 0.0
+ 1.200000000000e-07 0.0
+ 1.200200000000e-07 0.0
+ 1.220000000000e-07 0.0
+ 1.220200000000e-07 0.0
+ 1.240000000000e-07 0.0
+ 1.240200000000e-07 0.0
+ 1.260000000000e-07 0.0
+ 1.260200000000e-07 0.0
+ 1.280000000000e-07 0.0
+)
.tran 10p 128n
.measure tran v00z0 FIND V(z0) AT=1.8n
.measure tran v00z1 FIND V(z1) AT=1.8n
.measure tran v00z2 FIND V(z2) AT=1.8n
.measure tran v00z3 FIND V(z3) AT=1.8n
.measure tran v01z0 FIND V(z0) AT=3.8n
.measure tran v01z1 FIND V(z1) AT=3.8n
.measure tran v01z2 FIND V(z2) AT=3.8n
.measure tran v01z3 FIND V(z3) AT=3.8n
.measure tran v02z0 FIND V(z0) AT=5.8n
.measure tran v02z1 FIND V(z1) AT=5.8n
.measure tran v02z2 FIND V(z2) AT=5.8n
.measure tran v02z3 FIND V(z3) AT=5.8n
.measure tran v03z0 FIND V(z0) AT=7.8n
.measure tran v03z1 FIND V(z1) AT=7.8n
.measure tran v03z2 FIND V(z2) AT=7.8n
.measure tran v03z3 FIND V(z3) AT=7.8n
.measure tran v04z0 FIND V(z0) AT=9.8n
.measure tran v04z1 FIND V(z1) AT=9.8n
.measure tran v04z2 FIND V(z2) AT=9.8n
.measure tran v04z3 FIND V(z3) AT=9.8n
.measure tran v05z0 FIND V(z0) AT=11.8n
.measure tran v05z1 FIND V(z1) AT=11.8n
.measure tran v05z2 FIND V(z2) AT=11.8n
.measure tran v05z3 FIND V(z3) AT=11.8n
.measure tran v06z0 FIND V(z0) AT=13.8n
.measure tran v06z1 FIND V(z1) AT=13.8n
.measure tran v06z2 FIND V(z2) AT=13.8n
.measure tran v06z3 FIND V(z3) AT=13.8n
.measure tran v07z0 FIND V(z0) AT=15.8n
.measure tran v07z1 FIND V(z1) AT=15.8n
.measure tran v07z2 FIND V(z2) AT=15.8n
.measure tran v07z3 FIND V(z3) AT=15.8n
.measure tran v08z0 FIND V(z0) AT=17.8n
.measure tran v08z1 FIND V(z1) AT=17.8n
.measure tran v08z2 FIND V(z2) AT=17.8n
.measure tran v08z3 FIND V(z3) AT=17.8n
.measure tran v09z0 FIND V(z0) AT=19.8n
.measure tran v09z1 FIND V(z1) AT=19.8n
.measure tran v09z2 FIND V(z2) AT=19.8n
.measure tran v09z3 FIND V(z3) AT=19.8n
.measure tran v10z0 FIND V(z0) AT=21.8n
.measure tran v10z1 FIND V(z1) AT=21.8n
.measure tran v10z2 FIND V(z2) AT=21.8n
.measure tran v10z3 FIND V(z3) AT=21.8n
.measure tran v11z0 FIND V(z0) AT=23.8n
.measure tran v11z1 FIND V(z1) AT=23.8n
.measure tran v11z2 FIND V(z2) AT=23.8n
.measure tran v11z3 FIND V(z3) AT=23.8n
.measure tran v12z0 FIND V(z0) AT=25.8n
.measure tran v12z1 FIND V(z1) AT=25.8n
.measure tran v12z2 FIND V(z2) AT=25.8n
.measure tran v12z3 FIND V(z3) AT=25.8n
.measure tran v13z0 FIND V(z0) AT=27.8n
.measure tran v13z1 FIND V(z1) AT=27.8n
.measure tran v13z2 FIND V(z2) AT=27.8n
.measure tran v13z3 FIND V(z3) AT=27.8n
.measure tran v14z0 FIND V(z0) AT=29.8n
.measure tran v14z1 FIND V(z1) AT=29.8n
.measure tran v14z2 FIND V(z2) AT=29.8n
.measure tran v14z3 FIND V(z3) AT=29.8n
.measure tran v15z0 FIND V(z0) AT=31.8n
.measure tran v15z1 FIND V(z1) AT=31.8n
.measure tran v15z2 FIND V(z2) AT=31.8n
.measure tran v15z3 FIND V(z3) AT=31.8n
.measure tran v16z0 FIND V(z0) AT=33.8n
.measure tran v16z1 FIND V(z1) AT=33.8n
.measure tran v16z2 FIND V(z2) AT=33.8n
.measure tran v16z3 FIND V(z3) AT=33.8n
.measure tran v17z0 FIND V(z0) AT=35.8n
.measure tran v17z1 FIND V(z1) AT=35.8n
.measure tran v17z2 FIND V(z2) AT=35.8n
.measure tran v17z3 FIND V(z3) AT=35.8n
.measure tran v18z0 FIND V(z0) AT=37.8n
.measure tran v18z1 FIND V(z1) AT=37.8n
.measure tran v18z2 FIND V(z2) AT=37.8n
.measure tran v18z3 FIND V(z3) AT=37.8n
.measure tran v19z0 FIND V(z0) AT=39.8n
.measure tran v19z1 FIND V(z1) AT=39.8n
.measure tran v19z2 FIND V(z2) AT=39.8n
.measure tran v19z3 FIND V(z3) AT=39.8n
.measure tran v20z0 FIND V(z0) AT=41.8n
.measure tran v20z1 FIND V(z1) AT=41.8n
.measure tran v20z2 FIND V(z2) AT=41.8n
.measure tran v20z3 FIND V(z3) AT=41.8n
.measure tran v21z0 FIND V(z0) AT=43.8n
.measure tran v21z1 FIND V(z1) AT=43.8n
.measure tran v21z2 FIND V(z2) AT=43.8n
.measure tran v21z3 FIND V(z3) AT=43.8n
.measure tran v22z0 FIND V(z0) AT=45.8n
.measure tran v22z1 FIND V(z1) AT=45.8n
.measure tran v22z2 FIND V(z2) AT=45.8n
.measure tran v22z3 FIND V(z3) AT=45.8n
.measure tran v23z0 FIND V(z0) AT=47.8n
.measure tran v23z1 FIND V(z1) AT=47.8n
.measure tran v23z2 FIND V(z2) AT=47.8n
.measure tran v23z3 FIND V(z3) AT=47.8n
.measure tran v24z0 FIND V(z0) AT=49.8n
.measure tran v24z1 FIND V(z1) AT=49.8n
.measure tran v24z2 FIND V(z2) AT=49.8n
.measure tran v24z3 FIND V(z3) AT=49.8n
.measure tran v25z0 FIND V(z0) AT=51.8n
.measure tran v25z1 FIND V(z1) AT=51.8n
.measure tran v25z2 FIND V(z2) AT=51.8n
.measure tran v25z3 FIND V(z3) AT=51.8n
.measure tran v26z0 FIND V(z0) AT=53.8n
.measure tran v26z1 FIND V(z1) AT=53.8n
.measure tran v26z2 FIND V(z2) AT=53.8n
.measure tran v26z3 FIND V(z3) AT=53.8n
.measure tran v27z0 FIND V(z0) AT=55.8n
.measure tran v27z1 FIND V(z1) AT=55.8n
.measure tran v27z2 FIND V(z2) AT=55.8n
.measure tran v27z3 FIND V(z3) AT=55.8n
.measure tran v28z0 FIND V(z0) AT=57.8n
.measure tran v28z1 FIND V(z1) AT=57.8n
.measure tran v28z2 FIND V(z2) AT=57.8n
.measure tran v28z3 FIND V(z3) AT=57.8n
.measure tran v29z0 FIND V(z0) AT=59.8n
.measure tran v29z1 FIND V(z1) AT=59.8n
.measure tran v29z2 FIND V(z2) AT=59.8n
.measure tran v29z3 FIND V(z3) AT=59.8n
.measure tran v30z0 FIND V(z0) AT=61.8n
.measure tran v30z1 FIND V(z1) AT=61.8n
.measure tran v30z2 FIND V(z2) AT=61.8n
.measure tran v30z3 FIND V(z3) AT=61.8n
.measure tran v31z0 FIND V(z0) AT=63.8n
.measure tran v31z1 FIND V(z1) AT=63.8n
.measure tran v31z2 FIND V(z2) AT=63.8n
.measure tran v31z3 FIND V(z3) AT=63.8n
.measure tran v32z0 FIND V(z0) AT=65.8n
.measure tran v32z1 FIND V(z1) AT=65.8n
.measure tran v32z2 FIND V(z2) AT=65.8n
.measure tran v32z3 FIND V(z3) AT=65.8n
.measure tran v33z0 FIND V(z0) AT=67.8n
.measure tran v33z1 FIND V(z1) AT=67.8n
.measure tran v33z2 FIND V(z2) AT=67.8n
.measure tran v33z3 FIND V(z3) AT=67.8n
.measure tran v34z0 FIND V(z0) AT=69.8n
.measure tran v34z1 FIND V(z1) AT=69.8n
.measure tran v34z2 FIND V(z2) AT=69.8n
.measure tran v34z3 FIND V(z3) AT=69.8n
.measure tran v35z0 FIND V(z0) AT=71.8n
.measure tran v35z1 FIND V(z1) AT=71.8n
.measure tran v35z2 FIND V(z2) AT=71.8n
.measure tran v35z3 FIND V(z3) AT=71.8n
.measure tran v36z0 FIND V(z0) AT=73.8n
.measure tran v36z1 FIND V(z1) AT=73.8n
.measure tran v36z2 FIND V(z2) AT=73.8n
.measure tran v36z3 FIND V(z3) AT=73.8n
.measure tran v37z0 FIND V(z0) AT=75.8n
.measure tran v37z1 FIND V(z1) AT=75.8n
.measure tran v37z2 FIND V(z2) AT=75.8n
.measure tran v37z3 FIND V(z3) AT=75.8n
.measure tran v38z0 FIND V(z0) AT=77.8n
.measure tran v38z1 FIND V(z1) AT=77.8n
.measure tran v38z2 FIND V(z2) AT=77.8n
.measure tran v38z3 FIND V(z3) AT=77.8n
.measure tran v39z0 FIND V(z0) AT=79.8n
.measure tran v39z1 FIND V(z1) AT=79.8n
.measure tran v39z2 FIND V(z2) AT=79.8n
.measure tran v39z3 FIND V(z3) AT=79.8n
.measure tran v40z0 FIND V(z0) AT=81.8n
.measure tran v40z1 FIND V(z1) AT=81.8n
.measure tran v40z2 FIND V(z2) AT=81.8n
.measure tran v40z3 FIND V(z3) AT=81.8n
.measure tran v41z0 FIND V(z0) AT=83.8n
.measure tran v41z1 FIND V(z1) AT=83.8n
.measure tran v41z2 FIND V(z2) AT=83.8n
.measure tran v41z3 FIND V(z3) AT=83.8n
.measure tran v42z0 FIND V(z0) AT=85.8n
.measure tran v42z1 FIND V(z1) AT=85.8n
.measure tran v42z2 FIND V(z2) AT=85.8n
.measure tran v42z3 FIND V(z3) AT=85.8n
.measure tran v43z0 FIND V(z0) AT=87.8n
.measure tran v43z1 FIND V(z1) AT=87.8n
.measure tran v43z2 FIND V(z2) AT=87.8n
.measure tran v43z3 FIND V(z3) AT=87.8n
.measure tran v44z0 FIND V(z0) AT=89.8n
.measure tran v44z1 FIND V(z1) AT=89.8n
.measure tran v44z2 FIND V(z2) AT=89.8n
.measure tran v44z3 FIND V(z3) AT=89.8n
.measure tran v45z0 FIND V(z0) AT=91.8n
.measure tran v45z1 FIND V(z1) AT=91.8n
.measure tran v45z2 FIND V(z2) AT=91.8n
.measure tran v45z3 FIND V(z3) AT=91.8n
.measure tran v46z0 FIND V(z0) AT=93.8n
.measure tran v46z1 FIND V(z1) AT=93.8n
.measure tran v46z2 FIND V(z2) AT=93.8n
.measure tran v46z3 FIND V(z3) AT=93.8n
.measure tran v47z0 FIND V(z0) AT=95.8n
.measure tran v47z1 FIND V(z1) AT=95.8n
.measure tran v47z2 FIND V(z2) AT=95.8n
.measure tran v47z3 FIND V(z3) AT=95.8n
.measure tran v48z0 FIND V(z0) AT=97.8n
.measure tran v48z1 FIND V(z1) AT=97.8n
.measure tran v48z2 FIND V(z2) AT=97.8n
.measure tran v48z3 FIND V(z3) AT=97.8n
.measure tran v49z0 FIND V(z0) AT=99.8n
.measure tran v49z1 FIND V(z1) AT=99.8n
.measure tran v49z2 FIND V(z2) AT=99.8n
.measure tran v49z3 FIND V(z3) AT=99.8n
.measure tran v50z0 FIND V(z0) AT=101.8n
.measure tran v50z1 FIND V(z1) AT=101.8n
.measure tran v50z2 FIND V(z2) AT=101.8n
.measure tran v50z3 FIND V(z3) AT=101.8n
.measure tran v51z0 FIND V(z0) AT=103.8n
.measure tran v51z1 FIND V(z1) AT=103.8n
.measure tran v51z2 FIND V(z2) AT=103.8n
.measure tran v51z3 FIND V(z3) AT=103.8n
.measure tran v52z0 FIND V(z0) AT=105.8n
.measure tran v52z1 FIND V(z1) AT=105.8n
.measure tran v52z2 FIND V(z2) AT=105.8n
.measure tran v52z3 FIND V(z3) AT=105.8n
.measure tran v53z0 FIND V(z0) AT=107.8n
.measure tran v53z1 FIND V(z1) AT=107.8n
.measure tran v53z2 FIND V(z2) AT=107.8n
.measure tran v53z3 FIND V(z3) AT=107.8n
.measure tran v54z0 FIND V(z0) AT=109.8n
.measure tran v54z1 FIND V(z1) AT=109.8n
.measure tran v54z2 FIND V(z2) AT=109.8n
.measure tran v54z3 FIND V(z3) AT=109.8n
.measure tran v55z0 FIND V(z0) AT=111.8n
.measure tran v55z1 FIND V(z1) AT=111.8n
.measure tran v55z2 FIND V(z2) AT=111.8n
.measure tran v55z3 FIND V(z3) AT=111.8n
.measure tran v56z0 FIND V(z0) AT=113.8n
.measure tran v56z1 FIND V(z1) AT=113.8n
.measure tran v56z2 FIND V(z2) AT=113.8n
.measure tran v56z3 FIND V(z3) AT=113.8n
.measure tran v57z0 FIND V(z0) AT=115.8n
.measure tran v57z1 FIND V(z1) AT=115.8n
.measure tran v57z2 FIND V(z2) AT=115.8n
.measure tran v57z3 FIND V(z3) AT=115.8n
.measure tran v58z0 FIND V(z0) AT=117.8n
.measure tran v58z1 FIND V(z1) AT=117.8n
.measure tran v58z2 FIND V(z2) AT=117.8n
.measure tran v58z3 FIND V(z3) AT=117.8n
.measure tran v59z0 FIND V(z0) AT=119.8n
.measure tran v59z1 FIND V(z1) AT=119.8n
.measure tran v59z2 FIND V(z2) AT=119.8n
.measure tran v59z3 FIND V(z3) AT=119.8n
.measure tran v60z0 FIND V(z0) AT=121.8n
.measure tran v60z1 FIND V(z1) AT=121.8n
.measure tran v60z2 FIND V(z2) AT=121.8n
.measure tran v60z3 FIND V(z3) AT=121.8n
.measure tran v61z0 FIND V(z0) AT=123.8n
.measure tran v61z1 FIND V(z1) AT=123.8n
.measure tran v61z2 FIND V(z2) AT=123.8n
.measure tran v61z3 FIND V(z3) AT=123.8n
.measure tran v62z0 FIND V(z0) AT=125.8n
.measure tran v62z1 FIND V(z1) AT=125.8n
.measure tran v62z2 FIND V(z2) AT=125.8n
.measure tran v62z3 FIND V(z3) AT=125.8n
.measure tran v63z0 FIND V(z0) AT=127.8n
.measure tran v63z1 FIND V(z1) AT=127.8n
.measure tran v63z2 FIND V(z2) AT=127.8n
.measure tran v63z3 FIND V(z3) AT=127.8n
.end
