* 38T domino adder including 3 input inverters and weak keepers.
.param WN=0.47u PC=3.4060443770 PS=2.6544715309
.subckt domino a b ci clk co s nco vdd vss
MPIa ab a vdd vdd P_18 W='4*WN' L=0.18u AD='(4*WN)*0.18u' AS='(4*WN)*0.18u' PD='2*((4*WN)+0.18u)' PS='2*((4*WN)+0.18u)'
MNIa ab a vss vss N_18 W='WN' L=0.18u AD='(WN)*0.18u' AS='(WN)*0.18u' PD='2*((WN)+0.18u)' PS='2*((WN)+0.18u)'
MPIb bb b vdd vdd P_18 W='4*WN' L=0.18u AD='(4*WN)*0.18u' AS='(4*WN)*0.18u' PD='2*((4*WN)+0.18u)' PS='2*((4*WN)+0.18u)'
MNIb bb b vss vss N_18 W='WN' L=0.18u AD='(WN)*0.18u' AS='(WN)*0.18u' PD='2*((WN)+0.18u)' PS='2*((WN)+0.18u)'
MPIci cib ci vdd vdd P_18 W='4*WN' L=0.18u AD='(4*WN)*0.18u' AS='(4*WN)*0.18u' PD='2*((4*WN)+0.18u)' PS='2*((4*WN)+0.18u)'
MNIci cib ci vss vss N_18 W='WN' L=0.18u AD='(WN)*0.18u' AS='(WN)*0.18u' PD='2*((WN)+0.18u)' PS='2*((WN)+0.18u)'
McPRE cd clk vdd vdd P_18 W='4*WN' L=0.18u AD='(4*WN)*0.18u' AS='(4*WN)*0.18u' PD='2*((4*WN)+0.18u)' PS='2*((4*WN)+0.18u)'
McKEEP cd co vdd vdd P_18 W='WN' L=0.5u AD='(WN)*0.18u' AS='(WN)*0.18u' PD='2*((WN)+0.18u)' PS='2*((WN)+0.18u)'
McFOOT cf clk vss vss N_18 W='3*WN' L=0.18u AD='(3*WN)*0.18u' AS='(3*WN)*0.18u' PD='2*((3*WN)+0.18u)' PS='2*((3*WN)+0.18u)'
McN0 cd ci cm vss N_18 W='3*WN' L=0.18u AD='(3*WN)*0.18u' AS='(3*WN)*0.18u' PD='2*((3*WN)+0.18u)' PS='2*((3*WN)+0.18u)'
McN1 cm a cf vss N_18 W='3*WN' L=0.18u AD='(3*WN)*0.18u' AS='(3*WN)*0.18u' PD='2*((3*WN)+0.18u)' PS='2*((3*WN)+0.18u)'
McN2 cm b cf vss N_18 W='3*WN' L=0.18u AD='(3*WN)*0.18u' AS='(3*WN)*0.18u' PD='2*((3*WN)+0.18u)' PS='2*((3*WN)+0.18u)'
McN3 cd a cn vss N_18 W='3*WN' L=0.18u AD='(3*WN)*0.18u' AS='(3*WN)*0.18u' PD='2*((3*WN)+0.18u)' PS='2*((3*WN)+0.18u)'
McN4 cn b cf vss N_18 W='3*WN' L=0.18u AD='(3*WN)*0.18u' AS='(3*WN)*0.18u' PD='2*((3*WN)+0.18u)' PS='2*((3*WN)+0.18u)'
McOP co cd vdd vdd P_18 W='PC*WN' L=0.18u AD='(PC*WN)*0.18u' AS='(PC*WN)*0.18u' PD='2*((PC*WN)+0.18u)' PS='2*((PC*WN)+0.18u)'
McON co cd vss vss N_18 W='WN' L=0.18u AD='(WN)*0.18u' AS='(WN)*0.18u' PD='2*((WN)+0.18u)' PS='2*((WN)+0.18u)'
MncPRE ncd clk vdd vdd P_18 W='4*WN' L=0.18u AD='(4*WN)*0.18u' AS='(4*WN)*0.18u' PD='2*((4*WN)+0.18u)' PS='2*((4*WN)+0.18u)'
MncKEEP ncd nco vdd vdd P_18 W='WN' L=0.5u AD='(WN)*0.18u' AS='(WN)*0.18u' PD='2*((WN)+0.18u)' PS='2*((WN)+0.18u)'
MncFOOT ncf clk vss vss N_18 W='3*WN' L=0.18u AD='(3*WN)*0.18u' AS='(3*WN)*0.18u' PD='2*((3*WN)+0.18u)' PS='2*((3*WN)+0.18u)'
MncN0 ncd cib ncm vss N_18 W='3*WN' L=0.18u AD='(3*WN)*0.18u' AS='(3*WN)*0.18u' PD='2*((3*WN)+0.18u)' PS='2*((3*WN)+0.18u)'
MncN1 ncm ab ncf vss N_18 W='3*WN' L=0.18u AD='(3*WN)*0.18u' AS='(3*WN)*0.18u' PD='2*((3*WN)+0.18u)' PS='2*((3*WN)+0.18u)'
MncN2 ncm bb ncf vss N_18 W='3*WN' L=0.18u AD='(3*WN)*0.18u' AS='(3*WN)*0.18u' PD='2*((3*WN)+0.18u)' PS='2*((3*WN)+0.18u)'
MncN3 ncd ab ncn vss N_18 W='3*WN' L=0.18u AD='(3*WN)*0.18u' AS='(3*WN)*0.18u' PD='2*((3*WN)+0.18u)' PS='2*((3*WN)+0.18u)'
MncN4 ncn bb ncf vss N_18 W='3*WN' L=0.18u AD='(3*WN)*0.18u' AS='(3*WN)*0.18u' PD='2*((3*WN)+0.18u)' PS='2*((3*WN)+0.18u)'
MncOP nco ncd vdd vdd P_18 W='4*WN' L=0.18u AD='(4*WN)*0.18u' AS='(4*WN)*0.18u' PD='2*((4*WN)+0.18u)' PS='2*((4*WN)+0.18u)'
MncON nco ncd vss vss N_18 W='WN' L=0.18u AD='(WN)*0.18u' AS='(WN)*0.18u' PD='2*((WN)+0.18u)' PS='2*((WN)+0.18u)'
MSPRE sd clk vdd vdd P_18 W='4*WN' L=0.18u AD='(4*WN)*0.18u' AS='(4*WN)*0.18u' PD='2*((4*WN)+0.18u)' PS='2*((4*WN)+0.18u)'
MSKEEP sd s vdd vdd P_18 W='WN' L=0.5u AD='(WN)*0.18u' AS='(WN)*0.18u' PD='2*((WN)+0.18u)' PS='2*((WN)+0.18u)'
MSFOOT sf clk vss vss N_18 W='4*WN' L=0.18u AD='(4*WN)*0.18u' AS='(4*WN)*0.18u' PD='2*((4*WN)+0.18u)' PS='2*((4*WN)+0.18u)'
MSN0 sd nco sm vss N_18 W='3*WN' L=0.18u AD='(3*WN)*0.18u' AS='(3*WN)*0.18u' PD='2*((3*WN)+0.18u)' PS='2*((3*WN)+0.18u)'
MSN1 sm a sf vss N_18 W='3*WN' L=0.18u AD='(3*WN)*0.18u' AS='(3*WN)*0.18u' PD='2*((3*WN)+0.18u)' PS='2*((3*WN)+0.18u)'
MSN2 sm b sf vss N_18 W='3*WN' L=0.18u AD='(3*WN)*0.18u' AS='(3*WN)*0.18u' PD='2*((3*WN)+0.18u)' PS='2*((3*WN)+0.18u)'
MSN3 sm ci sf vss N_18 W='3*WN' L=0.18u AD='(3*WN)*0.18u' AS='(3*WN)*0.18u' PD='2*((3*WN)+0.18u)' PS='2*((3*WN)+0.18u)'
MSN4 sd a sn vss N_18 W='4*WN' L=0.18u AD='(4*WN)*0.18u' AS='(4*WN)*0.18u' PD='2*((4*WN)+0.18u)' PS='2*((4*WN)+0.18u)'
MSN5 sn b sp vss N_18 W='4*WN' L=0.18u AD='(4*WN)*0.18u' AS='(4*WN)*0.18u' PD='2*((4*WN)+0.18u)' PS='2*((4*WN)+0.18u)'
MSN6 sp ci sf vss N_18 W='4*WN' L=0.18u AD='(4*WN)*0.18u' AS='(4*WN)*0.18u' PD='2*((4*WN)+0.18u)' PS='2*((4*WN)+0.18u)'
MSOP s sd vdd vdd P_18 W='PS*WN' L=0.18u AD='(PS*WN)*0.18u' AS='(PS*WN)*0.18u' PD='2*((PS*WN)+0.18u)' PS='2*((PS*WN)+0.18u)'
MSON s sd vss vss N_18 W='WN' L=0.18u AD='(WN)*0.18u' AS='(WN)*0.18u' PD='2*((WN)+0.18u)' PS='2*((WN)+0.18u)'
.ends domino
