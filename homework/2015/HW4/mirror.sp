* 28T mirror adder; channel geometry and body ties are explicit.
.param WN=0.47u PG=4 PC=4.5052507348 PS=6.2749198768
.subckt mirror a b ci co s vdd vss
MNC0 cb ci Nc0 vss N_18 W='2*WN' L=0.18u AD='(2*WN)*0.18u' AS='(2*WN)*0.18u' PD='2*((2*WN)+0.18u)' PS='2*((2*WN)+0.18u)'
MNC1 Nc0 a vss vss N_18 W='2*WN' L=0.18u AD='(2*WN)*0.18u' AS='(2*WN)*0.18u' PD='2*((2*WN)+0.18u)' PS='2*((2*WN)+0.18u)'
MNC2 Nc0 b vss vss N_18 W='2*WN' L=0.18u AD='(2*WN)*0.18u' AS='(2*WN)*0.18u' PD='2*((2*WN)+0.18u)' PS='2*((2*WN)+0.18u)'
MNC3 cb a Nc1 vss N_18 W='2*WN' L=0.18u AD='(2*WN)*0.18u' AS='(2*WN)*0.18u' PD='2*((2*WN)+0.18u)' PS='2*((2*WN)+0.18u)'
MNC4 Nc1 b vss vss N_18 W='2*WN' L=0.18u AD='(2*WN)*0.18u' AS='(2*WN)*0.18u' PD='2*((2*WN)+0.18u)' PS='2*((2*WN)+0.18u)'
MNS0 sb cb Ns0 vss N_18 W='2*WN' L=0.18u AD='(2*WN)*0.18u' AS='(2*WN)*0.18u' PD='2*((2*WN)+0.18u)' PS='2*((2*WN)+0.18u)'
MNS1 Ns0 a vss vss N_18 W='2*WN' L=0.18u AD='(2*WN)*0.18u' AS='(2*WN)*0.18u' PD='2*((2*WN)+0.18u)' PS='2*((2*WN)+0.18u)'
MNS2 Ns0 b vss vss N_18 W='2*WN' L=0.18u AD='(2*WN)*0.18u' AS='(2*WN)*0.18u' PD='2*((2*WN)+0.18u)' PS='2*((2*WN)+0.18u)'
MNS3 Ns0 ci vss vss N_18 W='2*WN' L=0.18u AD='(2*WN)*0.18u' AS='(2*WN)*0.18u' PD='2*((2*WN)+0.18u)' PS='2*((2*WN)+0.18u)'
MNS4 sb a Ns1 vss N_18 W='3*WN' L=0.18u AD='(3*WN)*0.18u' AS='(3*WN)*0.18u' PD='2*((3*WN)+0.18u)' PS='2*((3*WN)+0.18u)'
MNS5 Ns1 b Ns2 vss N_18 W='3*WN' L=0.18u AD='(3*WN)*0.18u' AS='(3*WN)*0.18u' PD='2*((3*WN)+0.18u)' PS='2*((3*WN)+0.18u)'
MNS6 Ns2 ci vss vss N_18 W='3*WN' L=0.18u AD='(3*WN)*0.18u' AS='(3*WN)*0.18u' PD='2*((3*WN)+0.18u)' PS='2*((3*WN)+0.18u)'
MPC0 cb ci Pc0 vdd P_18 W='2*PG*WN' L=0.18u AD='(2*PG*WN)*0.18u' AS='(2*PG*WN)*0.18u' PD='2*((2*PG*WN)+0.18u)' PS='2*((2*PG*WN)+0.18u)'
MPC1 Pc0 a vdd vdd P_18 W='2*PG*WN' L=0.18u AD='(2*PG*WN)*0.18u' AS='(2*PG*WN)*0.18u' PD='2*((2*PG*WN)+0.18u)' PS='2*((2*PG*WN)+0.18u)'
MPC2 Pc0 b vdd vdd P_18 W='2*PG*WN' L=0.18u AD='(2*PG*WN)*0.18u' AS='(2*PG*WN)*0.18u' PD='2*((2*PG*WN)+0.18u)' PS='2*((2*PG*WN)+0.18u)'
MPC3 cb a Pc1 vdd P_18 W='2*PG*WN' L=0.18u AD='(2*PG*WN)*0.18u' AS='(2*PG*WN)*0.18u' PD='2*((2*PG*WN)+0.18u)' PS='2*((2*PG*WN)+0.18u)'
MPC4 Pc1 b vdd vdd P_18 W='2*PG*WN' L=0.18u AD='(2*PG*WN)*0.18u' AS='(2*PG*WN)*0.18u' PD='2*((2*PG*WN)+0.18u)' PS='2*((2*PG*WN)+0.18u)'
MPS0 sb cb Ps0 vdd P_18 W='2*PG*WN' L=0.18u AD='(2*PG*WN)*0.18u' AS='(2*PG*WN)*0.18u' PD='2*((2*PG*WN)+0.18u)' PS='2*((2*PG*WN)+0.18u)'
MPS1 Ps0 a vdd vdd P_18 W='2*PG*WN' L=0.18u AD='(2*PG*WN)*0.18u' AS='(2*PG*WN)*0.18u' PD='2*((2*PG*WN)+0.18u)' PS='2*((2*PG*WN)+0.18u)'
MPS2 Ps0 b vdd vdd P_18 W='2*PG*WN' L=0.18u AD='(2*PG*WN)*0.18u' AS='(2*PG*WN)*0.18u' PD='2*((2*PG*WN)+0.18u)' PS='2*((2*PG*WN)+0.18u)'
MPS3 Ps0 ci vdd vdd P_18 W='2*PG*WN' L=0.18u AD='(2*PG*WN)*0.18u' AS='(2*PG*WN)*0.18u' PD='2*((2*PG*WN)+0.18u)' PS='2*((2*PG*WN)+0.18u)'
MPS4 sb a Ps1 vdd P_18 W='3*PG*WN' L=0.18u AD='(3*PG*WN)*0.18u' AS='(3*PG*WN)*0.18u' PD='2*((3*PG*WN)+0.18u)' PS='2*((3*PG*WN)+0.18u)'
MPS5 Ps1 b Ps2 vdd P_18 W='3*PG*WN' L=0.18u AD='(3*PG*WN)*0.18u' AS='(3*PG*WN)*0.18u' PD='2*((3*PG*WN)+0.18u)' PS='2*((3*PG*WN)+0.18u)'
MPS6 Ps2 ci vdd vdd P_18 W='3*PG*WN' L=0.18u AD='(3*PG*WN)*0.18u' AS='(3*PG*WN)*0.18u' PD='2*((3*PG*WN)+0.18u)' PS='2*((3*PG*WN)+0.18u)'
MPco co cb vdd vdd P_18 W='PC*WN' L=0.18u AD='(PC*WN)*0.18u' AS='(PC*WN)*0.18u' PD='2*((PC*WN)+0.18u)' PS='2*((PC*WN)+0.18u)'
MNco co cb vss vss N_18 W='WN' L=0.18u AD='(WN)*0.18u' AS='(WN)*0.18u' PD='2*((WN)+0.18u)' PS='2*((WN)+0.18u)'
MPs s sb vdd vdd P_18 W='PS*WN' L=0.18u AD='(PS*WN)*0.18u' AS='(PS*WN)*0.18u' PD='2*((PS*WN)+0.18u)' PS='2*((PS*WN)+0.18u)'
MNs s sb vss vss N_18 W='WN' L=0.18u AD='(WN)*0.18u' AS='(WN)*0.18u' PD='2*((WN)+0.18u)' PS='2*((WN)+0.18u)'
.ends mirror
